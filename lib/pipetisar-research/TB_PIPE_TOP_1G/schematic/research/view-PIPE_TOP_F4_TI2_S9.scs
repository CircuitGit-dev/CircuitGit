// Explicit saved-library assembly.
simulator lang=spectre
include "Switch.scs"
include "PIPE_OTA_Diff_Ideal.scs"
include "PIPE_MDAC4_G8_SC.scs"
include "L4_stage1_flash_comparator.scs"
include "L4_stage1_flash_bootstrapper.scs"
include "L4_stage1_flash_clkbooster.scs"
include "L4_stage1_flash4_encoder.scs"
include "L4_stage1_flash4_rdac_FS2.scs"
include "L3_stage1_flash4_FS2.scs"
include "PIPE_TOP_F4_TI2_S9.scs"
