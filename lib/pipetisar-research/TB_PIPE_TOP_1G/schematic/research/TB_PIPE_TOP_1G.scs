// Generated for: spectre
include "L3_stage1_flash4_FS2.scs"
include "L4_stage1_flash4_encoder.scs"
include "L4_stage1_flash4_rdac_FS2.scs"
include "L4_stage1_flash_bootstrapper.scs"
include "L4_stage1_flash_clkbooster.scs"
include "L4_stage1_flash_comparator.scs"
include "PIPE_MDAC4_G8_SC.scs"
include "PIPE_OTA_Diff_Ideal.scs"
include "PIPE_TOP_F4_TI2_S9.scs"
include "Switch.scs"
// @RNL(type="header") {
//   @VERSION("0.3");
//   @USE-PACKAGE(name="rnl-std-spectre", version="0.3", path="rnl-std-spectre.rnl");
//   @USE-PACKAGE(name="eda-symbol", version="0.1", path="eda-symbol.rnl");
//   @USE-PACKAGE(name="eda-style", version="0.1", path="eda-style.rnl")
// }
// Generated on: Nov  9 19:45:40 2026
// Design library name: 2026_PIPETISAR_RESEARCH
// Design cell name: TB_PIPE_TOP_1G
// Design view name: schematic
simulator lang=spectre
global 0

// Library name: 2026_PIPETISAR_RESEARCH
// Cell name: Switch
// View name: schematic
// End of subcircuit definition.

// Library name: 2026_PIPETISAR_RESEARCH
// Cell name: PIPE_OTA_Diff_Ideal
// View name: schematic
// End of subcircuit definition.

// Library name: 2026_PIPETISAR_RESEARCH
// Cell name: PIPE_MDAC4_G8_SC
// View name: schematic
// End of subcircuit definition.

// Library name: tcbn28hpcplusbwp12t30p140ulvt
// Cell name: ND2D0BWP12T30P140ULVT
// View name: schematic
// End of subcircuit definition.

// Library name: tsmcN28
// Cell name: trans_ulvt_mac
// View name: schematic
// End of subcircuit definition.

// Library name: 2026_PIPETISAR_RESEARCH
// Cell name: L4_stage1_flash_comparator
// View name: schematic
// End of subcircuit definition.

// Library name: 2026_PIPETISAR_RESEARCH
// Cell name: L4_stage1_flash_bootstrapper
// View name: schematic
// End of subcircuit definition.

// Library name: 2026_PIPETISAR_RESEARCH
// Cell name: L4_stage1_flash_clkbooster
// View name: schematic
// End of subcircuit definition.

// Library name: 2026_PIPETISAR_RESEARCH
// Cell name: L4_stage1_flash4_encoder
// View name: schematic
// End of subcircuit definition.

// Library name: 2026_PIPETISAR_RESEARCH
// Cell name: L4_stage1_flash4_rdac_FS2
// View name: schematic
// End of subcircuit definition.

// Library name: 2026_PIPETISAR_RESEARCH
// Cell name: L3_stage1_flash4_FS2
// View name: schematic
// End of subcircuit definition.

// Library name: 2026_PIPETISAR_RESEARCH
// Cell name: PIPE_TOP_F4_TI2_S9
// View name: schematic
// End of subcircuit definition.

// Library name: 2026_PIPETISAR_RESEARCH
// Cell name: TB_PIPE_TOP_1G
// View name: schematic
XDUT (AMP BIN_3 BIN_2 BIN_1 BIN_0 CHANNEL CODE_11 CODE_10 CODE_9 CODE_8 \
        CODE_7 CODE_6 CODE_5 CODE_4 CODE_3 CODE_2 CODE_1 CODE_0 D_14 D_13 \
        D_12 D_11 D_10 D_9 D_8 D_7 D_6 D_5 D_4 D_3 D_2 D_1 D_0 DA DB IB_A \
        IB_B OVERFLOW RECON RON ROP TA TB TRACK VALID VCM VDD VINN VINP \
        VREFN VREFP 0) PIPE_TOP_F4_TI2_S9
VREFN0 (VREFN 0) vsource dc=Vcm-Vref/4 type=dc
VREFP0 (VREFP 0) vsource dc=Vcm+Vref/4 type=dc
VCM0 (VCM 0) vsource dc=Vcm type=dc
VDD0 (VDD 0) vsource dc=Vdd type=dc
VINN0 (VINN 0) vsource type=sine sinedc=Vcm ampl=-Ain/2 freq=Fin
VINP0 (VINP 0) vsource type=sine sinedc=Vcm ampl=Ain/2 freq=Fin
IBIAS_B (VDD IB_B) isource dc=Iref type=dc
IBIAS_A (VDD IB_A) isource dc=Iref type=dc
CPROBE14 (DB 0) capacitor c=1a
CPROBE13 (DA 0) capacitor c=1a
CPROBE12 (TB 0) capacitor c=1a
CPROBE11 (TA 0) capacitor c=1a
CPROBE10 (AMP 0) capacitor c=1a
CPROBE9 (TRACK 0) capacitor c=1a
CPROBE8_3 (BIN_3 0) capacitor c=1a
CPROBE8_2 (BIN_2 0) capacitor c=1a
CPROBE8_1 (BIN_1 0) capacitor c=1a
CPROBE8_0 (BIN_0 0) capacitor c=1a
CPROBE7_14 (D_14 0) capacitor c=1a
CPROBE7_13 (D_13 0) capacitor c=1a
CPROBE7_12 (D_12 0) capacitor c=1a
CPROBE7_11 (D_11 0) capacitor c=1a
CPROBE7_10 (D_10 0) capacitor c=1a
CPROBE7_9 (D_9 0) capacitor c=1a
CPROBE7_8 (D_8 0) capacitor c=1a
CPROBE7_7 (D_7 0) capacitor c=1a
CPROBE7_6 (D_6 0) capacitor c=1a
CPROBE7_5 (D_5 0) capacitor c=1a
CPROBE7_4 (D_4 0) capacitor c=1a
CPROBE7_3 (D_3 0) capacitor c=1a
CPROBE7_2 (D_2 0) capacitor c=1a
CPROBE7_1 (D_1 0) capacitor c=1a
CPROBE7_0 (D_0 0) capacitor c=1a
CPROBE6 (RON 0) capacitor c=1a
CPROBE5 (ROP 0) capacitor c=1a
CPROBE4 (OVERFLOW 0) capacitor c=1a
CPROBE3 (CHANNEL 0) capacitor c=1a
CPROBE2 (RECON 0) capacitor c=1a
CPROBE1 (VALID 0) capacitor c=1a
CPROBE0_11 (CODE_11 0) capacitor c=1a
CPROBE0_10 (CODE_10 0) capacitor c=1a
CPROBE0_9 (CODE_9 0) capacitor c=1a
CPROBE0_8 (CODE_8 0) capacitor c=1a
CPROBE0_7 (CODE_7 0) capacitor c=1a
CPROBE0_6 (CODE_6 0) capacitor c=1a
CPROBE0_5 (CODE_5 0) capacitor c=1a
CPROBE0_4 (CODE_4 0) capacitor c=1a
CPROBE0_3 (CODE_3 0) capacitor c=1a
CPROBE0_2 (CODE_2 0) capacitor c=1a
CPROBE0_1 (CODE_1 0) capacitor c=1a
CPROBE0_0 (CODE_0 0) capacitor c=1a
// @RNL(author="rnl-virtuoso") {
//   #"CPROBE6" @SET-SYMBOL $CAPACITOR;
//   #"CPROBE6" @PLACE(0, -151.8) => @ORIENT("R0");
//   %bundle_0 = {#"CPROBE0_11" #"CPROBE0_10" #"CPROBE0_9" #"CPROBE0_8" #"CPROBE0_7" #"CPROBE0_6" #"CPROBE0_5" #"CPROBE0_4" #"CPROBE0_3" #"CPROBE0_2" #"CPROBE0_1" #"CPROBE0_0"} @BUNDLE;
//   %bundle_0 @SET-SYMBOL $CAPACITOR;
//   %bundle_0 @PLACE(153.6, -151.8) => @ORIENT("R0");
//   %bundle_0 @TEXT("CPROBE0<11:0>", key="name");
//   #"VDD0" @SET-SYMBOL $VOLTAGE_SOURCE;
//   #"VDD0" @PLACE(0, 45) => @ORIENT("R0");
//   #"XDUT" @PLACE(96, 0) => @ORIENT("R0");
//   %bundle_1 = {#"CPROBE7_14" #"CPROBE7_13" #"CPROBE7_12" #"CPROBE7_11" #"CPROBE7_10" #"CPROBE7_9" #"CPROBE7_8" #"CPROBE7_7" #"CPROBE7_6" #"CPROBE7_5" #"CPROBE7_4" #"CPROBE7_3" #"CPROBE7_2" #"CPROBE7_1" #"CPROBE7_0"} @BUNDLE;
//   %bundle_1 @SET-SYMBOL $CAPACITOR;
//   %bundle_1 @PLACE(179.2, -123) => @ORIENT("R0");
//   %bundle_1 @TEXT("CPROBE7<14:0>", key="name");
//   #"CPROBE13" @SET-SYMBOL $CAPACITOR;
//   #"CPROBE13" @PLACE(25.6, -123) => @ORIENT("R0");
//   #"VCM0" @SET-SYMBOL $VOLTAGE_SOURCE;
//   #"VCM0" @PLACE(32, 45) => @ORIENT("R0");
//   #"CPROBE2" @SET-SYMBOL $CAPACITOR;
//   #"CPROBE2" @PLACE(102.4, -151.8) => @ORIENT("R0");
//   #"CPROBE11" @SET-SYMBOL $CAPACITOR;
//   #"CPROBE11" @PLACE(76.8, -123) => @ORIENT("R0");
//   #"VINP0" @SET-SYMBOL $VSIN;
//   #"VINP0" @PLACE(16, -3) => @ORIENT("R0");
//   #"CPROBE1" @SET-SYMBOL $CAPACITOR;
//   #"CPROBE1" @PLACE(128, -151.8) => @ORIENT("R0");
//   #"IBIAS_B" @SET-SYMBOL $CURRENT_SOURCE;
//   #"IBIAS_B" @PLACE(160, 45) => @ORIENT("R0");
//   #"CPROBE5" @SET-SYMBOL $CAPACITOR;
//   #"CPROBE5" @PLACE(25.6, -151.8) => @ORIENT("R0");
//   %bundle_2 = {#"CPROBE8_3" #"CPROBE8_2" #"CPROBE8_1" #"CPROBE8_0"} @BUNDLE;
//   %bundle_2 @SET-SYMBOL $CAPACITOR;
//   %bundle_2 @PLACE(153.6, -123) => @ORIENT("R0");
//   %bundle_2 @TEXT("CPROBE8<3:0>", key="name");
//   #"CPROBE12" @SET-SYMBOL $CAPACITOR;
//   #"CPROBE12" @PLACE(51.2, -123) => @ORIENT("R0");
//   #"CPROBE14" @SET-SYMBOL $CAPACITOR;
//   #"CPROBE14" @PLACE(0, -123) => @ORIENT("R0");
//   #"IBIAS_A" @SET-SYMBOL $CURRENT_SOURCE;
//   #"IBIAS_A" @PLACE(128, 45) => @ORIENT("R0");
//   #"CPROBE3" @SET-SYMBOL $CAPACITOR;
//   #"CPROBE3" @PLACE(76.8, -151.8) => @ORIENT("R0");
//   #"CPROBE4" @SET-SYMBOL $CAPACITOR;
//   #"CPROBE4" @PLACE(51.2, -151.8) => @ORIENT("R0");
//   #"VINN0" @SET-SYMBOL $VSIN;
//   #"VINN0" @PLACE(16, -35) => @ORIENT("R0");
//   #"CPROBE10" @SET-SYMBOL $CAPACITOR;
//   #"CPROBE10" @PLACE(102.4, -123) => @ORIENT("R0");
//   #"VREFN0" @SET-SYMBOL $VOLTAGE_SOURCE;
//   #"VREFN0" @PLACE(96, 45) => @ORIENT("R0");
//   #"VREFP0" @SET-SYMBOL $VOLTAGE_SOURCE;
//   #"VREFP0" @PLACE(64, 45) => @ORIENT("R0");
//   #"CPROBE9" @SET-SYMBOL $CAPACITOR;
//   #"CPROBE9" @PLACE(128, -123) => @ORIENT("R0");
//   %marker_52 = $GROUND @ATTACH &"0" => @PLACE(16, -64) => @ORIENT("R0");
//   %p0 = (153.6, -129.5);
//   %wire_0 = &"0" @WIRE(mode="straight") {%p0 %bundle_2:2};
//   %wire_0 @TEXT("<*4>gnd!", size=1.9, halign="start", valign="top") => @PLACE(154.2, -130);
//   %p1 = (153.6, -158.3);
//   %wire_1 = &"0" @WIRE(mode="straight") {%p1 %bundle_0:2};
//   %wire_1 @TEXT("<*12>gnd!", size=1.9, halign="start", valign="top") => @PLACE(154.2, -158.8);
//   %p2 = (92.5, -24);
//   %wire_2 = &"0" @WIRE(mode="straight") {%p2 #"XDUT":52};
//   %p3 = (96, 38.5);
//   %wire_3 = &"0" @WIRE(mode="straight") {%p3 #"VREFN0":2};
//   %p4 = (64, 38.5);
//   %wire_4 = &"0" @WIRE(mode="straight") {%p4 #"VREFP0":2};
//   %p5 = (32, 38.5);
//   %wire_5 = &"0" @WIRE(mode="straight") {%p5 #"VCM0":2};
//   %p6 = (0, 38.5);
//   %wire_6 = &"0" @WIRE(mode="straight") {%p6 #"VDD0":2};
//   %p7 = (16, -41.5);
//   %wire_7 = &"0" @WIRE(mode="straight") {%p7 #"VINN0":2};
//   %p8 = (16, -9.5);
//   %wire_8 = &"0" @WIRE(mode="straight") {%p8 #"VINP0":2};
//   %p9 = (16, -60.5);
//   %wire_9 = &"0" @WIRE(mode="straight") {%marker_52:p %p9};
//   %p10 = (0, -129.5);
//   %wire_10 = &"0" @WIRE(mode="straight") {%p10 #"CPROBE14":2};
//   %p11 = (25.6, -129.5);
//   %wire_11 = &"0" @WIRE(mode="straight") {%p11 #"CPROBE13":2};
//   %p12 = (51.2, -129.5);
//   %wire_12 = &"0" @WIRE(mode="straight") {%p12 #"CPROBE12":2};
//   %p13 = (76.8, -129.5);
//   %wire_13 = &"0" @WIRE(mode="straight") {%p13 #"CPROBE11":2};
//   %p14 = (102.4, -129.5);
//   %wire_14 = &"0" @WIRE(mode="straight") {%p14 #"CPROBE10":2};
//   %p15 = (128, -129.5);
//   %wire_15 = &"0" @WIRE(mode="straight") {%p15 #"CPROBE9":2};
//   %p16 = (0, -158.3);
//   %wire_16 = &"0" @WIRE(mode="straight") {%p16 #"CPROBE6":2};
//   %p17 = (25.6, -158.3);
//   %wire_17 = &"0" @WIRE(mode="straight") {%p17 #"CPROBE5":2};
//   %p18 = (51.2, -158.3);
//   %wire_18 = &"0" @WIRE(mode="straight") {%p18 #"CPROBE4":2};
//   %p19 = (76.8, -158.3);
//   %wire_19 = &"0" @WIRE(mode="straight") {%p19 #"CPROBE3":2};
//   %p20 = (102.4, -158.3);
//   %wire_20 = &"0" @WIRE(mode="straight") {%p20 #"CPROBE2":2};
//   %p21 = (128, -158.3);
//   %wire_21 = &"0" @WIRE(mode="straight") {%p21 #"CPROBE1":2};
//   %wire_21 @TEXT("0", size=1.9, halign="start", valign="top") => @PLACE(128.6, -158.8);
//   %wire_20 @TEXT("0", size=1.9, halign="start", valign="top") => @PLACE(103, -158.8);
//   %wire_19 @TEXT("0", size=1.9, halign="start", valign="top") => @PLACE(77.4, -158.8);
//   %wire_18 @TEXT("0", size=1.9, halign="start", valign="top") => @PLACE(51.8, -158.8);
//   %wire_17 @TEXT("0", size=1.9, halign="start", valign="top") => @PLACE(26.2, -158.8);
//   %wire_16 @TEXT("0", size=1.9, halign="start", valign="top") => @PLACE(0.6, -158.8);
//   %wire_15 @TEXT("0", size=1.9, halign="start", valign="top") => @PLACE(128.6, -130);
//   %wire_14 @TEXT("0", size=1.9, halign="start", valign="top") => @PLACE(103, -130);
//   %wire_13 @TEXT("0", size=1.9, halign="start", valign="top") => @PLACE(77.4, -130);
//   %wire_12 @TEXT("0", size=1.9, halign="start", valign="top") => @PLACE(51.8, -130);
//   %wire_11 @TEXT("0", size=1.9, halign="start", valign="top") => @PLACE(26.2, -130);
//   %wire_10 @TEXT("0", size=1.9, halign="start", valign="top") => @PLACE(0.6, -130);
//   %wire_9 @TEXT("0", size=2.4, halign="start", valign="baseline") => @PLACE(16.6, -60);
//   %wire_8 @TEXT("0", size=2.4, halign="start", valign="top") => @PLACE(16.6, -10);
//   %wire_7 @TEXT("0", size=2.4, halign="start", valign="top") => @PLACE(16.6, -42);
//   %wire_6 @TEXT("0", size=2.4, halign="start", valign="top") => @PLACE(0.6, 38);
//   %wire_5 @TEXT("0", size=2.4, halign="start", valign="top") => @PLACE(32.6, 38);
//   %wire_4 @TEXT("0", size=2.4, halign="start", valign="top") => @PLACE(64.6, 38);
//   %wire_3 @TEXT("0", size=2.4, halign="start", valign="top") => @PLACE(96.6, 38);
//   %wire_2 @TEXT("0", size=2.4, halign="end", valign="middle") => @PLACE(90.9, -24);
//   %p22 = (179.2, -129.5);
//   %wire_22 = &"0" @WIRE(mode="straight") {%p22 %bundle_1:2};
//   %wire_22 @TEXT("<*15>gnd!", size=1.9, halign="start", valign="top") => @PLACE(179.8, -130);
//   %p23 = (92.5, -8);
//   %wire_23 = &"VREFP" @WIRE(mode="straight") {%p23 #"XDUT":51};
//   %p24 = (64, 51.5);
//   %wire_24 = &"VREFP" @WIRE(mode="straight") {#"VREFP0":1 %p24};
//   %wire_24 @TEXT("VREFP", size=2.4, halign="start", valign="baseline") => @PLACE(64.6, 52);
//   %wire_23 @TEXT("VREFP", size=2.4, halign="end", valign="middle") => @PLACE(90.9, -8);
//   %p25 = (92.5, -12);
//   %wire_25 = &"VREFN" @WIRE(mode="straight") {%p25 #"XDUT":50};
//   %p26 = (96, 51.5);
//   %wire_26 = &"VREFN" @WIRE(mode="straight") {#"VREFN0":1 %p26};
//   %wire_26 @TEXT("VREFN", size=2.4, halign="start", valign="baseline") => @PLACE(96.6, 52);
//   %wire_25 @TEXT("VREFN", size=2.4, halign="end", valign="middle") => @PLACE(90.9, -12);
//   %wire_27 = &"VINP" @WIRE(mode="straight") {#"VINP0":1 #"XDUT":49};
//   %wire_27 @TEXT("VINP", size=2.4, halign="middle", valign="baseline") => @PLACE(56, 0);
//   %p27 = (56, -32);
//   %wire_28 = &"VINN" @WIRE(mode="straight") {#"VINN0":1 %p27};
//   %p28 = (56, -4);
//   %wire_29 = &"VINN" @WIRE(mode="straight") {%p27 %p28};
//   %wire_30 = &"VINN" @WIRE(mode="straight") {%p28 #"XDUT":48};
//   %wire_28 @TEXT("VINN", size=2.4, halign="middle", valign="baseline") => @PLACE(36, -32);
//   %p29 = (92.5, -20);
//   %wire_31 = &"VDD" @WIRE(mode="straight") {%p29 #"XDUT":47};
//   %p30 = (0, 51.5);
//   %wire_32 = &"VDD" @WIRE(mode="straight") {#"VDD0":1 %p30};
//   %p31 = (160, 51.5);
//   %wire_33 = &"VDD" @WIRE(mode="straight") {#"IBIAS_B":1 %p31};
//   %p32 = (128, 51.5);
//   %wire_34 = &"VDD" @WIRE(mode="straight") {#"IBIAS_A":1 %p32};
//   %wire_34 @TEXT("VDD", size=2.4, halign="start", valign="baseline") => @PLACE(128.6, 52);
//   %wire_33 @TEXT("VDD", size=2.4, halign="start", valign="baseline") => @PLACE(160.6, 52);
//   %wire_32 @TEXT("VDD", size=2.4, halign="start", valign="baseline") => @PLACE(0.6, 52);
//   %wire_31 @TEXT("VDD", size=2.4, halign="end", valign="middle") => @PLACE(90.9, -20);
//   %p33 = (92.5, -16);
//   %wire_35 = &"VCM" @WIRE(mode="straight") {%p33 #"XDUT":46};
//   %p34 = (32, 51.5);
//   %wire_36 = &"VCM" @WIRE(mode="straight") {#"VCM0":1 %p34};
//   %wire_36 @TEXT("VCM", size=2.4, halign="start", valign="baseline") => @PLACE(32.6, 52);
//   %wire_35 @TEXT("VCM", size=2.4, halign="end", valign="middle") => @PLACE(90.9, -16);
//   %p35 = (158.7, -8);
//   %wire_37 = &"VALID" @WIRE(mode="straight") {#"XDUT":45 %p35};
//   %p36 = (128, -145.3);
//   %wire_38 = &"VALID" @WIRE(mode="straight") {#"CPROBE1":1 %p36};
//   %wire_38 @TEXT("VALID", size=1.9, halign="start", valign="baseline") => @PLACE(128.6, -144.8);
//   %wire_37 @TEXT("VALID", size=2.4, halign="start", valign="middle") => @PLACE(160.3, -8);
//   %p37 = (158.7, -32);
//   %wire_39 = &"TRACK" @WIRE(mode="straight") {#"XDUT":44 %p37};
//   %p38 = (128, -116.5);
//   %wire_40 = &"TRACK" @WIRE(mode="straight") {#"CPROBE9":1 %p38};
//   %wire_40 @TEXT("TRACK", size=1.9, halign="start", valign="baseline") => @PLACE(128.6, -116);
//   %wire_39 @TEXT("TRACK", size=2.4, halign="start", valign="middle") => @PLACE(160.3, -32);
//   %p39 = (158.7, -44);
//   %wire_41 = &"TB" @WIRE(mode="straight") {#"XDUT":43 %p39};
//   %p40 = (51.2, -116.5);
//   %wire_42 = &"TB" @WIRE(mode="straight") {#"CPROBE12":1 %p40};
//   %wire_42 @TEXT("TB", size=1.9, halign="start", valign="baseline") => @PLACE(51.8, -116);
//   %wire_41 @TEXT("TB", size=2.4, halign="start", valign="middle") => @PLACE(160.3, -44);
//   %p41 = (158.7, -40);
//   %wire_43 = &"TA" @WIRE(mode="straight") {#"XDUT":42 %p41};
//   %p42 = (76.8, -116.5);
//   %wire_44 = &"TA" @WIRE(mode="straight") {#"CPROBE11":1 %p42};
//   %wire_44 @TEXT("TA", size=1.9, halign="start", valign="baseline") => @PLACE(77.4, -116);
//   %wire_43 @TEXT("TA", size=2.4, halign="start", valign="middle") => @PLACE(160.3, -40);
//   %p43 = (158.7, -16);
//   %wire_45 = &"ROP" @WIRE(mode="straight") {#"XDUT":41 %p43};
//   %p44 = (25.6, -145.3);
//   %wire_46 = &"ROP" @WIRE(mode="straight") {#"CPROBE5":1 %p44};
//   %wire_46 @TEXT("ROP", size=1.9, halign="start", valign="baseline") => @PLACE(26.2, -144.8);
//   %wire_45 @TEXT("ROP", size=2.4, halign="start", valign="middle") => @PLACE(160.3, -16);
//   %p45 = (158.7, -20);
//   %wire_47 = &"RON" @WIRE(mode="straight") {#"XDUT":40 %p45};
//   %p46 = (0, -145.3);
//   %wire_48 = &"RON" @WIRE(mode="straight") {#"CPROBE6":1 %p46};
//   %wire_48 @TEXT("RON", size=1.9, halign="start", valign="baseline") => @PLACE(0.6, -144.8);
//   %wire_47 @TEXT("RON", size=2.4, halign="start", valign="middle") => @PLACE(160.3, -20);
//   %p47 = (158.7, -4);
//   %wire_49 = &"RECON" @WIRE(mode="straight") {#"XDUT":39 %p47};
//   %p48 = (102.4, -145.3);
//   %wire_50 = &"RECON" @WIRE(mode="straight") {#"CPROBE2":1 %p48};
//   %wire_50 @TEXT("RECON", size=1.9, halign="start", valign="baseline") => @PLACE(103, -144.8);
//   %wire_49 @TEXT("RECON", size=2.4, halign="start", valign="middle") => @PLACE(160.3, -4);
//   %p49 = (158.7, -12);
//   %wire_51 = &"OVERFLOW" @WIRE(mode="straight") {#"XDUT":38 %p49};
//   %p50 = (51.2, -145.3);
//   %wire_52 = &"OVERFLOW" @WIRE(mode="straight") {#"CPROBE4":1 %p50};
//   %wire_52 @TEXT("OVERFLOW", size=1.9, halign="start", valign="baseline") => @PLACE(51.8, -144.8);
//   %wire_51 @TEXT("OVERFLOW", size=2.4, halign="start", valign="middle") => @PLACE(160.3, -12);
//   %p51 = (92.5, -32);
//   %wire_53 = &"IB_B" @WIRE(mode="straight") {%p51 #"XDUT":37};
//   %p52 = (160, 38.5);
//   %wire_54 = &"IB_B" @WIRE(mode="straight") {%p52 #"IBIAS_B":2};
//   %wire_54 @TEXT("IB\_B", size=2.4, halign="start", valign="top") => @PLACE(160.6, 38);
//   %wire_53 @TEXT("IB\_B", size=2.4, halign="end", valign="middle") => @PLACE(90.9, -32);
//   %p53 = (92.5, -28);
//   %wire_55 = &"IB_A" @WIRE(mode="straight") {%p53 #"XDUT":36};
//   %p54 = (128, 38.5);
//   %wire_56 = &"IB_A" @WIRE(mode="straight") {%p54 #"IBIAS_A":2};
//   %wire_56 @TEXT("IB\_A", size=2.4, halign="start", valign="top") => @PLACE(128.6, 38);
//   %wire_55 @TEXT("IB\_A", size=2.4, halign="end", valign="middle") => @PLACE(90.9, -28);
//   %p55 = (158.7, -52);
//   %wire_57 = &"DB" @WIRE(mode="straight") {#"XDUT":35 %p55};
//   %p56 = (0, -116.5);
//   %wire_58 = &"DB" @WIRE(mode="straight") {#"CPROBE14":1 %p56};
//   %wire_58 @TEXT("DB", size=1.9, halign="start", valign="baseline") => @PLACE(0.6, -116);
//   %wire_57 @TEXT("DB", size=2.4, halign="start", valign="middle") => @PLACE(160.3, -52);
//   %p57 = (158.7, -48);
//   %wire_59 = &"DA" @WIRE(mode="straight") {#"XDUT":34 %p57};
//   %p58 = (25.6, -116.5);
//   %wire_60 = &"DA" @WIRE(mode="straight") {#"CPROBE13":1 %p58};
//   %wire_60 @TEXT("DA", size=1.9, halign="start", valign="baseline") => @PLACE(26.2, -116);
//   %wire_59 @TEXT("DA", size=2.4, halign="start", valign="middle") => @PLACE(160.3, -48);
//   %p59 = (158.7, -56);
//   %wire_61 = &"CHANNEL" @WIRE(mode="straight") {#"XDUT":6 %p59};
//   %p60 = (76.8, -145.3);
//   %wire_62 = &"CHANNEL" @WIRE(mode="straight") {#"CPROBE3":1 %p60};
//   %wire_62 @TEXT("CHANNEL", size=1.9, halign="start", valign="baseline") => @PLACE(77.4, -144.8);
//   %wire_61 @TEXT("CHANNEL", size=2.4, halign="start", valign="middle") => @PLACE(160.3, -56);
//   %p61 = (158.7, -36);
//   %wire_63 = &"AMP" @WIRE(mode="straight") {#"XDUT":1 %p61};
//   %p62 = (102.4, -116.5);
//   %wire_64 = &"AMP" @WIRE(mode="straight") {#"CPROBE10":1 %p62};
//   %wire_64 @TEXT("AMP", size=1.9, halign="start", valign="baseline") => @PLACE(103, -116);
//   %wire_63 @TEXT("AMP", size=2.4, halign="start", valign="middle") => @PLACE(160.3, -36);
//   %p63 = (158.7, -28);
//   %wire_65 = {&"BIN_3" &"BIN_2" &"BIN_1" &"BIN_0"} @WIRE(mode="straight") {#"XDUT":2 %p63};
//   %p64 = (153.6, -116.5);
//   %wire_66 = {&"BIN_3" &"BIN_2" &"BIN_1" &"BIN_0"} @WIRE(mode="straight") {%bundle_2:1 %p64};
//   %wire_66 @TEXT("BIN<3:0>", size=1.9, halign="start", valign="baseline") => @PLACE(154.2, -116);
//   %wire_65 @TEXT("BIN<3:0>", size=2.4, halign="start", valign="middle") => @PLACE(160.3, -28);
//   %p65 = (158.7, 0);
//   %wire_67 = {&"CODE_11" &"CODE_10" &"CODE_9" &"CODE_8" &"CODE_7" &"CODE_6" &"CODE_5" &"CODE_4" &"CODE_3" &"CODE_2" &"CODE_1" &"CODE_0"} @WIRE(mode="straight") {#"XDUT":7 %p65};
//   %p66 = (153.6, -145.3);
//   %wire_68 = {&"CODE_11" &"CODE_10" &"CODE_9" &"CODE_8" &"CODE_7" &"CODE_6" &"CODE_5" &"CODE_4" &"CODE_3" &"CODE_2" &"CODE_1" &"CODE_0"} @WIRE(mode="straight") {%bundle_0:1 %p66};
//   %wire_68 @TEXT("CODE<11:0>", size=1.9, halign="start", valign="baseline") => @PLACE(154.2, -144.8);
//   %wire_67 @TEXT("CODE<11:0>", size=2.4, halign="start", valign="middle") => @PLACE(160.3, 0);
//   %p67 = (158.7, -24);
//   %wire_69 = {&"D_14" &"D_13" &"D_12" &"D_11" &"D_10" &"D_9" &"D_8" &"D_7" &"D_6" &"D_5" &"D_4" &"D_3" &"D_2" &"D_1" &"D_0"} @WIRE(mode="straight") {#"XDUT":19 %p67};
//   %p68 = (179.2, -116.5);
//   %wire_70 = {&"D_14" &"D_13" &"D_12" &"D_11" &"D_10" &"D_9" &"D_8" &"D_7" &"D_6" &"D_5" &"D_4" &"D_3" &"D_2" &"D_1" &"D_0"} @WIRE(mode="straight") {%bundle_1:1 %p68};
//   %wire_70 @TEXT("D<14:0>", size=1.9, halign="start", valign="baseline") => @PLACE(179.8, -116);
//   %wire_69 @TEXT("D<14:0>", size=2.4, halign="start", valign="middle") => @PLACE(160.3, -24);
//   (0, -104) @TEXT("Probe capacitors below are 1aF; output timing / loading is unchanged.", size=2.7, halign="start", valign="baseline");
//   (0, -84.8) @TEXT("Maestro: 01 input / 02 Flash reconstruction / 03 RA output 04 final reconstruction / 05 sampled output; 11-19 clocks", size=3.2, halign="start", valign="baseline");
//   (199.6, 64.8) @TEXT("KEY OUTPUTS D<14:0>: first Flash code ROP/RON: residue output CODE<11:0>: final code VALID: final code ready", size=3, halign="start", valign="baseline");
//   (0, 24) @TEXT("DIFFERENTIAL SINE INPUT", size=3.2, halign="start", valign="baseline");
//   (0, 68) @TEXT("SUPPLIES + REFERENCES + BIAS", size=3.2, halign="start", valign="baseline");
//   (0, 80) @TEXT("PIPE ADC / VDD=1V / DIFF FS=2Vpp", size=4.8, halign="start", valign="baseline");
//   (0, 89.6) @TEXT("TIMING DIAGRAM: PIPE\_TIMING\_1G / schematic (enlarged view)", size=3.5, halign="start", valign="baseline");
//   (203, 32.2) @TEXT("1GS/s PIPELINE TIMING / THREE CONSECUTIVE SAMPLES", size=3.2, halign="start", valign="baseline");
//   (203, 25.2) @TEXT("0-250ps SAMPLE | 250-500ps FLASH | 500-1000ps AMPLIFY", size=2.6, halign="start", valign="baseline");
//   (255.7, 17.9) @TEXT("0", size=1.8, halign="start", valign="baseline");
//   (271.7, 17.9) @TEXT("0.25", size=1.8, halign="start", valign="baseline");
//   (287.7, 17.9) @TEXT("0.5", size=1.8, halign="start", valign="baseline");
//   (319.7, 17.9) @TEXT("1", size=1.8, halign="start", valign="baseline");
//   (335.7, 17.9) @TEXT("1.25", size=1.8, halign="start", valign="baseline");
//   (351.7, 17.9) @TEXT("1.5", size=1.8, halign="start", valign="baseline");
//   (383.7, 17.9) @TEXT("2", size=1.8, halign="start", valign="baseline");
//   (399.7, 17.9) @TEXT("2.25", size=1.8, halign="start", valign="baseline");
//   (415.7, 17.9) @TEXT("2.5", size=1.8, halign="start", valign="baseline");
//   (447.7, 17.9) @TEXT("3", size=1.8, halign="start", valign="baseline");
//   (461.6, 17.9) @TEXT("ns", size=1.8, halign="start", valign="baseline");
//   (203, 13.6) @TEXT("TRACK / S1", size=2.2, halign="start", valign="baseline");
//   (203, 4.9) @TEXT("PHI1EN / latch", size=2.2, halign="start", valign="baseline");
//   (203, -3.8) @TEXT("PHI1N / auxiliary", size=2.2, halign="start", valign="baseline");
//   (203, -12.5) @TEXT("PHI2P / code out", size=2.2, halign="start", valign="baseline");
//   (203, -21.2) @TEXT("AMP / MDAC", size=2.2, halign="start", valign="baseline");
//   (203, -29.9) @TEXT("RESET / Cf", size=2.2, halign="start", valign="baseline");
//   (203, -38.6) @TEXT("TA / A track", size=2.2, halign="start", valign="baseline");
//   (203, -47.3) @TEXT("TB / B track", size=2.2, halign="start", valign="baseline");
//   (203, -56) @TEXT("SAR A convert", size=2.2, halign="start", valign="baseline");
//   (203, -64.7) @TEXT("SAR B convert", size=2.2, halign="start", valign="baseline");
//   (203, -73.4) @TEXT("VALID / output", size=2.2, halign="start", valign="baseline");
//   (203, -89.4) @TEXT("A captures x0 @0.99ns -> Q ready @2.09ns; B captures x1 @1.99ns -> Q @3.09ns.", size=2.2, halign="start", valign="baseline");
//   (203, -94.5) @TEXT("Each SAR: 100ps startup + 9 x 100ps decisions + 100ps commit = 1.10ns.", size=2.2, halign="start", valign="baseline");
//   (203, -99.6) @TEXT("FFT: D + (ROP-RON)/8 sampled together @nT+0.980ns; final CODE @nT+2.15ns.", size=2.2, halign="start", valign="baseline");
//   (203, -104.8) @TEXT("PHI2N is the inverse of PHI2P. RESET releases at498ps and asserts at998ps.", size=2.2, halign="start", valign="baseline");
//   (203, -109.9) @TEXT("Digital flags shown schematically; physical edges have 1ps rise/fall.", size=2.2, halign="start", valign="baseline");
//   (0, 99.2) @TEXT("VDD=1V; VCM=0.5V; quantizer FS=2Vpp differential Ain is differential PEAK (independent of full scale). Default 0.9V => 1.8Vpp.", size=2.9, halign="start", valign="baseline");
//   (0, -174.2) @TEXT("VALIDATION: Interactive.9 / VDD=1V / FSdiff=2Vpp", size=3.2, halign="start", valign="baseline");
//   (0, -180.6) @TEXT("05: final code shifted 1.90ns to input sample time", size=3.2, halign="start", valign="baseline");
//   (0, -187) @TEXT("09: actual held input; 10: final minus held (uV)", size=3.2, halign="start", valign="baseline");
//   (0, -193.4) @TEXT("Half LSB =244.14uV; both 44ns tests pass", size=3.2, halign="start", valign="baseline");
//   @LINE {(256.8, 13) (256.8, 13) (256.8, 16.5) (272.8, 16.5) (272.8, 13) (320.8, 13) (320.8, 16.5) (336.8, 16.5) (336.8, 13) (384.8, 13) (384.8, 16.5) (400.8, 16.5) (400.8, 13) (461.6, 13)};
//   @LINE {(256.8, 4.3) (272.8, 4.3) (272.8, 7.8) (320.8, 7.8) (320.8, 4.3) (336.8, 4.3) (336.8, 7.8) (384.8, 7.8) (384.8, 4.3) (400.8, 4.3) (400.8, 7.8) (448.8, 7.8) (448.8, 4.3) (461.6, 4.3)};
//   @LINE {(256.8, -4.4) (274, -4.4) (274, -1) (320.8, -1) (320.8, -4.4) (338, -4.4) (338, -1) (384.8, -1) (384.8, -4.4) (402, -4.4) (402, -1) (448.8, -1) (448.8, -4.4) (461.6, -4.4)};
//   @LINE {(256.8, -13.1) (288.8, -13.1) (288.8, -9.7) (319.8, -9.7) (319.8, -13.1) (352.8, -13.1) (352.8, -9.7) (383.8, -9.7) (383.8, -13.1) (416.8, -13.1) (416.8, -9.7) (447.8, -9.7) (447.8, -13.1) (461.6, -13.1)};
//   @LINE {(256.8, -21.8) (288.8, -21.8) (288.8, -18.4) (320.8, -18.4) (320.8, -21.8) (352.8, -21.8) (352.8, -18.4) (384.8, -18.4) (384.8, -21.8) (416.8, -21.8) (416.8, -18.4) (448.8, -18.4) (448.8, -21.8) (461.6, -21.8)};
//   @LINE {(256.8, -30.5) (256.8, -30.5) (256.8, -27.1) (288.6, -27.1) (288.6, -30.5) (320.6, -30.5) (320.6, -27.1) (352.6, -27.1) (352.6, -30.5) (384.6, -30.5) (384.6, -27.1) (416.6, -27.1) (416.6, -30.5) (448.6, -30.5) (448.6, -27.1) (461.6, -27.1) (461.6, -30.5) (461.6, -30.5)};
//   @LINE {(256.8, -39.2) (288.8, -39.2) (288.8, -35.8) (320.1, -35.8) (320.1, -39.2) (416.8, -39.2) (416.8, -35.8) (448.1, -35.8) (448.1, -39.2) (461.6, -39.2)};
//   @LINE {(256.8, -47.9) (352.8, -47.9) (352.8, -44.5) (384.1, -44.5) (384.1, -47.9) (461.6, -47.9)};
//   @LINE {(256.8, -56.6) (320.1, -56.6) (320.1, -53.2) (390.5, -53.2) (390.5, -56.6) (448.1, -56.6) (448.1, -53.2) (461.6, -53.2) (461.6, -56.6) (461.6, -56.6)};
//   @LINE {(256.8, -65.3) (384.1, -65.3) (384.1, -61.9) (454.5, -61.9) (454.5, -65.3) (461.6, -65.3)};
//   @LINE {(256.8, -74) (392.2, -74) (392.2, -70.6) (397.3, -70.6) (397.3, -74) (456.2, -74) (456.2, -70.6) (461.3, -70.6) (461.3, -74) (461.6, -74)}
// }
// External behavioral implementation omitted from read-only viewer.
// External behavioral implementation omitted from read-only viewer.
// External behavioral implementation omitted from read-only viewer.
// External behavioral implementation omitted from read-only viewer.
// External behavioral implementation omitted from read-only viewer.
