// @RNL(type="header") {
// @VERSION("0.3");
// @USE-PACKAGE(name="rnl-std-spectre", version="0.3", path="rnl-std-spectre.rnl");
// @USE-PACKAGE(name="eda-symbol", version="0.1", path="eda-symbol.rnl");
// @USE-PACKAGE(name="eda-style", version="0.1", path="eda-style.rnl")
// }
// Design: 2026_PIPETISAR_RESEARCH/MDAC4_MOM_BIT_N06
simulator lang=spectre
global 0

// 2026_PIPETISAR_RESEARCH/Switch/schematic

// 2026_PIPETISAR_RESEARCH/MDAC4_MOM_BIT_N06/schematic
subckt MDAC4_MOM_BIT_N06 BN BP H HB L LB TRACK VDD VINN VINP VREFN VREFP VSS XN XP
    CN (BN XP) cfmom_2t nr=60 lr=3.2u w=50n s=50n stm=2 spm=7 multi=1
    CP (BP XN) cfmom_2t nr=60 lr=3.2u w=50n s=50n stm=2 spm=7 multi=1
    SN (VINN BN TRACK) Switch Rseries=0.1
    SP (VINP BP TRACK) Switch Rseries=0.1
    MNH (BN LB VREFP VDD) pch_hvt_mac l=60n w=500n multi=4 nf=1
    MPH (BP HB VREFP VDD) pch_hvt_mac l=60n w=500n multi=4 nf=1
    MNL (BN H VREFN VSS) nch_hvt_mac l=60n w=500n multi=4 nf=1
    MPL (BP L VREFN VSS) nch_hvt_mac l=60n w=500n multi=4 nf=1
// @RNL(author="rnl-virtuoso") {
// %block_symbol = @DEFINE-SYMBOL(box=[0, -68, 44.8, 4]) {
// @RECTANGLE {(0, -68) (44.8, 4)};
// (22.4, 8.8) @TEXT("MOM + REF MOS", size=3.8, halign="middle", valign="middle");
// ? @TEXT("${name}", size=2.9, halign="middle", valign="middle", key="name") => @PLACE(22.4, -72.3);
// (0, 0) @PIN(terminal="VINP");
// (1.6, 0) @TEXT("VINP", size=2.6, halign="start", valign="middle");
// (0, -6.4) @PIN(terminal="VINN");
// (1.6, -6.4) @TEXT("VINN", size=2.6, halign="start", valign="middle");
// (0, -12.8) @PIN(terminal="TRACK");
// (1.6, -12.8) @TEXT("TRACK", size=2.6, halign="start", valign="middle");
// (0, -19.2) @PIN(terminal="H");
// (1.6, -19.2) @TEXT("H", size=2.6, halign="start", valign="middle");
// (0, -25.6) @PIN(terminal="HB");
// (1.6, -25.6) @TEXT("HB", size=2.6, halign="start", valign="middle");
// (0, -32) @PIN(terminal="L");
// (1.6, -32) @TEXT("L", size=2.6, halign="start", valign="middle");
// (0, -38.4) @PIN(terminal="LB");
// (1.6, -38.4) @TEXT("LB", size=2.6, halign="start", valign="middle");
// (0, -44.8) @PIN(terminal="VREFP");
// (1.6, -44.8) @TEXT("VREFP", size=2.6, halign="start", valign="middle");
// (0, -51.2) @PIN(terminal="VREFN");
// (1.6, -51.2) @TEXT("VREFN", size=2.6, halign="start", valign="middle");
// (0, -57.6) @PIN(terminal="VDD");
// (1.6, -57.6) @TEXT("VDD", size=2.6, halign="start", valign="middle");
// (0, -64) @PIN(terminal="VSS");
// (1.6, -64) @TEXT("VSS", size=2.6, halign="start", valign="middle");
// (44.8, 0) @PIN(terminal="XN");
// (43.2, 0) @TEXT("XN", size=2.6, halign="end", valign="middle");
// (44.8, -6.4) @PIN(terminal="XP");
// (43.2, -6.4) @TEXT("XP", size=2.6, halign="end", valign="middle");
// (44.8, -12.8) @PIN(terminal="BP");
// (43.2, -12.8) @TEXT("BP", size=2.6, halign="end", valign="middle");
// (44.8, -19.2) @PIN(terminal="BN");
// (43.2, -19.2) @TEXT("BN", size=2.6, halign="end", valign="middle")
// };
// # @SET-SYMBOL %block_symbol;
// %symbol_0 = @DEFINE-SYMBOL(box=[-0.1, -2.8, 3.8, 2.8]) {
// @LINE {(2, 1.5) (4, 1.5) (4, 3)};
// @LINE {(2, -1.5) (2, 1.5)};
// @LINE {(3, -1) (4, -1.5) (3, -2)};
// @LINE {(0, 0) (1.5, 0)};
// @LINE {(1.5, 1.5) (1.5, -1.5)};
// @LINE {(2, -1.5) (4, -1.5) (4, -3)};
// ? @TEXT("${name}", size=0.8, halign="start", valign="baseline", key="name") => @PLACE(5, 3.5);
// ? @TEXT("${model}", size=0.8, halign="end", valign="baseline", key="model") => @PLACE(3.2, 3.2);
// (4, -1) @PIN(terminal=4);
// (4, -3) @PIN(terminal=3);
// (4, 3) @PIN(terminal=1);
// (0, 0) @PIN(terminal=2)
// };
// #"MNL" @SET-SYMBOL %symbol_0;
// #"MNL" @PLACE(32, -28.8) => @ORIENT("R0");
// %symbol_1 = @DEFINE-SYMBOL(box=[-0.1, -2.8, 3.8, 2.8]) {
// @LINE {(0, 0) (0.7, 0)};
// @LINE {(1.5, 1.5) (1.5, -1.5)};
// @LINE {(2, -1.5) (4, -1.5) (4, -3)};
// @LINE {(2, 1.5) (4, 1.5) (4, 3)};
// (1.1, 0) @CIRCLE(radius=0.4);
// @LINE {(3.7, 2) (2.7, 1.5) (3.7, 1)};
// @LINE {(2, -1.5) (2, 1.5)};
// ? @TEXT("${name}", size=0.8, halign="start", valign="baseline", key="name") => @PLACE(4.9, 3.4);
// ? @TEXT("${model}", size=0.8, halign="end", valign="baseline", key="model") => @PLACE(3.3, 3.2);
// (4, 3) @PIN(terminal=3);
// (4, 1) @PIN(terminal=4);
// (0, 0) @PIN(terminal=2);
// (4, -3) @PIN(terminal=1)
// };
// #"MPH" @SET-SYMBOL %symbol_1;
// #"MPH" @PLACE(32, 30.4) => @ORIENT("R0");
// #"MNH" @SET-SYMBOL %symbol_1;
// #"MNH" @PLACE(32, -9.6) => @ORIENT("R0");
// #"MPL" @SET-SYMBOL %symbol_0;
// #"MPL" @PLACE(32, 11.2) => @ORIENT("R0");
// %symbol_2 = @DEFINE-SYMBOL(box=[-2, -6, 2, 0]) {
// @LINE {(1, -2.2) (-1, -2.2)};
// @LINE {(0, 0) (0, -2.2)};
// @LINE {(0, -2.8) (0, -6)};
// @ARC {(1, -3.2) (0, -2.8) (-1, -3.2)};
// ? @TEXT("${name}", size=0.8, halign="start", valign="baseline", key="name") => @PLACE(1.4, 0.1);
// ? @TEXT("${model}", size=0.8, halign="end", valign="baseline", key="model") => @PLACE(-1.1, 0.3);
// (0, 0) @PIN(terminal=1);
// (0, -6) @PIN(terminal=2)
// };
// #"CN" @SET-SYMBOL %symbol_2;
// #"CN" @PLACE(56, -19.2) => @ORIENT("R90");
// #"SN" @PLACE(0, -19.2) => @ORIENT("R0");
// #"CP" @SET-SYMBOL %symbol_2;
// #"CP" @PLACE(56, 20.8) => @ORIENT("R90");
// #"SP" @PLACE(0, 20.8) => @ORIENT("R0");
// %input_port_symbol = @DEFINE-SYMBOL(box=[-2, -1, 0, 1]) {
// @LINE(fill="linecolor", linestyle="none") {(-2, -0.9) (-2, 0.9) (-0.9, 0.9) (0, 0) (-0.9, -0.9) (-2, -0.9)};
// (0, 0) @PIN(terminal=1, direction="right");
// ? @TEXT("${name}", key="name", halign="middle") => @PLACE(-1, 1.6)
// };
// %port_0 = $IO_PORT @ATTACH &"VSS" => @PLACE(44.8, -51.2) => @ORIENT("R0");
// %port_0 @SET-SYMBOL %input_port_symbol;
// %port_0 @TEXT("VSS", key="name");
// %port_1 = $IO_PORT @ATTACH &"VDD" => @PLACE(25.6, -51.2) => @ORIENT("R0");
// %port_1 @SET-SYMBOL %input_port_symbol;
// %port_1 @TEXT("VDD", key="name");
// %port_2 = $IO_PORT @ATTACH &"VREFN" => @PLACE(6.4, -51.2) => @ORIENT("R0");
// %port_2 @SET-SYMBOL %input_port_symbol;
// %port_2 @TEXT("VREFN", key="name");
// %port_3 = $IO_PORT @ATTACH &"VREFP" => @PLACE(-12.8, -51.2) => @ORIENT("R0");
// %port_3 @SET-SYMBOL %input_port_symbol;
// %port_3 @TEXT("VREFP", key="name");
// %port_4 = $IO_PORT @ATTACH &"LB" => @PLACE(64, -42.4) => @ORIENT("R0");
// %port_4 @SET-SYMBOL %input_port_symbol;
// %port_4 @TEXT("LB", key="name");
// %port_5 = $IO_PORT @ATTACH &"L" => @PLACE(44.8, -42.4) => @ORIENT("R0");
// %port_5 @SET-SYMBOL %input_port_symbol;
// %port_5 @TEXT("L", key="name");
// %port_6 = $IO_PORT @ATTACH &"HB" => @PLACE(25.6, -42.4) => @ORIENT("R0");
// %port_6 @SET-SYMBOL %input_port_symbol;
// %port_6 @TEXT("HB", key="name");
// %port_7 = $IO_PORT @ATTACH &"H" => @PLACE(6.4, -42.4) => @ORIENT("R0");
// %port_7 @SET-SYMBOL %input_port_symbol;
// %port_7 @TEXT("H", key="name");
// %port_8 = $IO_PORT @ATTACH &"TRACK" => @PLACE(-12.8, -42.4) => @ORIENT("R0");
// %port_8 @SET-SYMBOL %input_port_symbol;
// %port_8 @TEXT("TRACK", key="name");
// %port_9 = $IO_PORT @ATTACH &"BN" => @PLACE(49.6, -24) => @ORIENT("R0");
// %port_10 = $IO_PORT @ATTACH &"XP" => @PLACE(73.6, -19.2) => @ORIENT("R0");
// %port_11 = $IO_PORT @ATTACH &"VINN" => @PLACE(-12.8, -19.2) => @ORIENT("R0");
// %port_11 @SET-SYMBOL %input_port_symbol;
// %port_11 @TEXT("VINN", key="name");
// %port_12 = $IO_PORT @ATTACH &"BP" => @PLACE(49.6, 16) => @ORIENT("R0");
// %port_13 = $IO_PORT @ATTACH &"XN" => @PLACE(73.6, 20.8) => @ORIENT("R0");
// %port_14 = $IO_PORT @ATTACH &"VINP" => @PLACE(-12.8, 20.8) => @ORIENT("R0");
// %port_14 @SET-SYMBOL %input_port_symbol;
// %port_14 @TEXT("VINP", key="name");
// %p0 = (50.4, -51.2);
// %wire_0 = &"VSS" @WIRE(mode="straight") {%port_0:p %p0};
// %p1 = (38.4, 10.2);
// %wire_1 = &"VSS" @WIRE(mode="straight") {#"MPL":4 %p1};
// %p2 = (38.4, -29.8);
// %wire_2 = &"VSS" @WIRE(mode="straight") {#"MNL":4 %p2};
// %wire_2 @TEXT("VSS", size=1.6, halign="start", valign="middle") => @PLACE(39.2, -29.8);
// %wire_1 @TEXT("VSS", size=1.6, halign="start", valign="middle") => @PLACE(39.2, 10.2);
// %p3 = (31.2, -51.2);
// %wire_3 = &"VDD" @WIRE(mode="straight") {%port_1:p %p3};
// %p4 = (38.4, 31.4);
// %wire_4 = &"VDD" @WIRE(mode="straight") {#"MPH":4 %p4};
// %p5 = (38.4, -8.6);
// %wire_5 = &"VDD" @WIRE(mode="straight") {#"MNH":4 %p5};
// %wire_5 @TEXT("VDD", size=1.6, halign="start", valign="middle") => @PLACE(39.2, -8.6);
// %wire_4 @TEXT("VDD", size=1.6, halign="start", valign="middle") => @PLACE(39.2, 31.4);
// %p6 = (12, -51.2);
// %wire_6 = &"VREFN" @WIRE(mode="straight") {%port_2:p %p6};
// %p7 = (36, 5.8);
// %wire_7 = &"VREFN" @WIRE(mode="straight") {%p7 #"MPL":3};
// %p8 = (36, -34.2);
// %wire_8 = &"VREFN" @WIRE(mode="straight") {%p8 #"MNL":3};
// %wire_8 @TEXT("VREFN", size=1.6, halign="middle", valign="top") => @PLACE(36, -35);
// %wire_7 @TEXT("VREFN", size=1.6, halign="middle", valign="top") => @PLACE(36, 5);
// %p9 = (-7.2, -51.2);
// %wire_9 = &"VREFP" @WIRE(mode="straight") {%port_3:p %p9};
// %p10 = (36, 35.8);
// %wire_10 = &"VREFP" @WIRE(mode="straight") {#"MPH":3 %p10};
// %p11 = (36, -4.2);
// %wire_11 = &"VREFP" @WIRE(mode="straight") {#"MNH":3 %p11};
// %wire_11 @TEXT("VREFP", size=1.6, halign="middle", valign="baseline") => @PLACE(36, -3.4);
// %wire_10 @TEXT("VREFP", size=1.6, halign="middle", valign="baseline") => @PLACE(36, 36.6);
// %p12 = (69.6, -42.4);
// %wire_12 = &"LB" @WIRE(mode="straight") {%port_4:p %p12};
// %p13 = (29.6, -9.6);
// %wire_13 = &"LB" @WIRE(mode="straight") {%p13 #"MNH":2};
// %wire_13 @TEXT("LB", size=1.6, halign="end", valign="middle") => @PLACE(28.8, -9.6);
// %p14 = (50.4, -42.4);
// %wire_14 = &"L" @WIRE(mode="straight") {%port_5:p %p14};
// %p15 = (29.6, 11.2);
// %wire_15 = &"L" @WIRE(mode="straight") {%p15 #"MPL":2};
// %wire_15 @TEXT("L", size=1.6, halign="end", valign="middle") => @PLACE(28.8, 11.2);
// %p16 = (31.2, -42.4);
// %wire_16 = &"HB" @WIRE(mode="straight") {%port_6:p %p16};
// %p17 = (29.6, 30.4);
// %wire_17 = &"HB" @WIRE(mode="straight") {%p17 #"MPH":2};
// %wire_17 @TEXT("HB", size=1.6, halign="end", valign="middle") => @PLACE(28.8, 30.4);
// %p18 = (12, -42.4);
// %wire_18 = &"H" @WIRE(mode="straight") {%port_7:p %p18};
// %p19 = (29.6, -28.8);
// %wire_19 = &"H" @WIRE(mode="straight") {%p19 #"MNL":2};
// %wire_19 @TEXT("H", size=1.6, halign="end", valign="middle") => @PLACE(28.8, -28.8);
// %p20 = (-7.2, -42.4);
// %wire_20 = &"TRACK" @WIRE(mode="straight") {%port_8:p %p20};
// %p21 = (4, 25.2);
// %wire_21 = &"TRACK" @WIRE(mode="straight") {#"SP":3 %p21};
// %p22 = (4, -14.8);
// %wire_22 = &"TRACK" @WIRE(mode="straight") {#"SN":3 %p22};
// %wire_22 @TEXT("TRACK", size=1.6, halign="middle", valign="baseline") => @PLACE(4, -14);
// %wire_21 @TEXT("TRACK", size=1.6, halign="middle", valign="baseline") => @PLACE(4, 26);
// %p23 = (49.6, -19.2);
// %wire_23 = &"BN" @WIRE(mode="straight") {#"SN":2 %p23};
// %p24 = (49.6, -12.6);
// %wire_24 = &"BN" @WIRE(mode="straight") {#"MNH":1 %p24};
// %wire_25 = &"BN" @WIRE(mode="straight") {%p23 #"CN":1};
// %wire_26 = &"BN" @WIRE(mode="straight") {%p23 %p24};
// %p25 = (49.6, -25.8);
// %wire_27 = &"BN" @WIRE(mode="straight") {#"MNL":1 %p25};
// %wire_28 = &"BN" @WIRE(mode="straight") {%p25 %port_9:p};
// %wire_29 = &"BN" @WIRE(mode="straight") {%port_9:p %p23};
// %wire_27 @TEXT("BN", size=1.6, halign="middle", valign="baseline") => @PLACE(42.8, -25.2);
// %wire_24 @TEXT("BN", size=1.6, halign="middle", valign="baseline") => @PLACE(42.8, -12);
// %wire_23 @TEXT("BN", size=1.6, halign="middle", valign="baseline") => @PLACE(32, -18.6);
// %wire_30 = &"XP" @WIRE(mode="straight") {#"CN":2 %port_10:p};
// %wire_31 = &"VINN" @WIRE(mode="straight") {%port_11:p #"SN":1};
// %p26 = (49.6, 20.8);
// %wire_32 = &"BP" @WIRE(mode="straight") {#"SP":2 %p26};
// %p27 = (49.6, 27.4);
// %wire_33 = &"BP" @WIRE(mode="straight") {#"MPH":1 %p27};
// %wire_34 = &"BP" @WIRE(mode="straight") {%p26 #"CP":1};
// %wire_35 = &"BP" @WIRE(mode="straight") {%p26 %p27};
// %p28 = (49.6, 14.2);
// %wire_36 = &"BP" @WIRE(mode="straight") {#"MPL":1 %p28};
// %wire_37 = &"BP" @WIRE(mode="straight") {%p28 %port_12:p};
// %wire_38 = &"BP" @WIRE(mode="straight") {%port_12:p %p26};
// %wire_36 @TEXT("BP", size=1.6, halign="middle", valign="baseline") => @PLACE(42.8, 14.8);
// %wire_33 @TEXT("BP", size=1.6, halign="middle", valign="baseline") => @PLACE(42.8, 28);
// %wire_32 @TEXT("BP", size=1.6, halign="middle", valign="baseline") => @PLACE(32, 21.4);
// %wire_39 = &"XN" @WIRE(mode="straight") {#"CP":2 %port_13:p};
// %wire_40 = &"VINP" @WIRE(mode="straight") {%port_14:p #"SP":1};
// $JUNCTION @ATTACH %p23;
// $JUNCTION @ATTACH %p26;
// (-12.8, -64) @TEXT("H=AMP*K; L=AMP*!K; HB and LB are complementary drives.", size=2.2, halign="start", valign="baseline");
// (-12.8, -71.2) @TEXT("Sampling Switch is ideal; reference MOS and MOM are PDK devices.", size=2.2, halign="start", valign="baseline");
// (-12.8, 45.6) @TEXT("Differential capacitor / reference-switch unit", size=3.5, halign="start", valign="baseline");
// (25.6, -49.3) @TEXT("VDD", size=2.2, halign="start", valign="baseline");
// (-12.8, 38.4) @TEXT("Cu = 99.86fF MOM; reference MOS: HVT / L=60nm / W=500nm x4.", size=2.1, halign="start", valign="baseline");
// (-12.8, -49.3) @TEXT("VREFP", size=2.2, halign="start", valign="baseline");
// (6.4, -49.3) @TEXT("VREFN", size=2.2, halign="start", valign="baseline");
// (64, -40.5) @TEXT("LB", size=2.2, halign="start", valign="baseline");
// (44.8, -40.5) @TEXT("L", size=2.2, halign="start", valign="baseline");
// (44.8, -49.3) @TEXT("VSS", size=2.2, halign="start", valign="baseline");
// (25.6, -40.5) @TEXT("HB", size=2.2, halign="start", valign="baseline");
// (6.4, -40.5) @TEXT("H", size=2.2, halign="start", valign="baseline");
// (-12.8, -40.5) @TEXT("TRACK", size=2.2, halign="start", valign="baseline");
// (49.6, -22.1) @TEXT("BN", size=2.2, halign="start", valign="baseline");
// (73.6, -17.3) @TEXT("XP", size=2.2, halign="start", valign="baseline");
// (-12.8, -17.3) @TEXT("VINN", size=2.2, halign="start", valign="baseline");
// (49.6, 17.9) @TEXT("BP", size=2.2, halign="start", valign="baseline");
// (73.6, 22.7) @TEXT("XN", size=2.2, halign="start", valign="baseline");
// (-12.8, 22.7) @TEXT("VINP", size=2.2, halign="start", valign="baseline")
// }
ends MDAC4_MOM_BIT_N06
