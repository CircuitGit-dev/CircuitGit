simulator lang=spectre
// Explicit waveform dependencies; keep raw bits out of Maestro Outputs.
save VINP
save VINN
save ROP
save RON
save TRACK
save AMP
save TA
save TB
save DA
save DB
save VALID
save CHANNEL
save OVERFLOW
save RECON
save XDUT.PHI1EN
save XDUT.VHA
save XDUT.VHB
save XDUT.HAP
save XDUT.HAN
save XDUT.HBP
save XDUT.HBN
save D\<0\>
save D\<1\>
save D\<2\>
save D\<3\>
save D\<4\>
save D\<5\>
save D\<6\>
save D\<7\>
save D\<8\>
save D\<9\>
save D\<10\>
save D\<11\>
save D\<12\>
save D\<13\>
save D\<14\>
save CODE\<0\>
save CODE\<1\>
save CODE\<2\>
save CODE\<3\>
save CODE\<4\>
save CODE\<5\>
save CODE\<6\>
save CODE\<7\>
save CODE\<8\>
save CODE\<9\>
save CODE\<10\>
save CODE\<11\>
save XDUT.KA\<0\>
save XDUT.KA\<1\>
save XDUT.KA\<2\>
save XDUT.KA\<3\>
save XDUT.KB\<0\>
save XDUT.KB\<1\>
save XDUT.KB\<2\>
save XDUT.KB\<3\>
save XDUT.QA\<0\>
save XDUT.QA\<1\>
save XDUT.QA\<2\>
save XDUT.QA\<3\>
save XDUT.QA\<4\>
save XDUT.QA\<5\>
save XDUT.QA\<6\>
save XDUT.QA\<7\>
save XDUT.QA\<8\>
save XDUT.QB\<0\>
save XDUT.QB\<1\>
save XDUT.QB\<2\>
save XDUT.QB\<3\>
save XDUT.QB\<4\>
save XDUT.QB\<5\>
save XDUT.QB\<6\>
save XDUT.QB\<7\>
save XDUT.QB\<8\>
save XDUT.XSARA.EOC
save XDUT.XSARA.CLKC
save XDUT.XSARA.CLKA
save XDUT.XSARA.CLKAE
save XDUT.XSARA.CLKB
save XDUT.XSARA.CLKD
save XDUT.XSARA.STEP
save XDUT.XSARA.BUSY
save XDUT.XSARA.OVF
save XDUT.XSARB.EOC
save XDUT.XSARB.CLKC
save XDUT.XSARB.CLKA
save XDUT.XSARB.CLKAE
save XDUT.XSARB.CLKB
save XDUT.XSARB.CLKD
save XDUT.XSARB.STEP
save XDUT.XSARB.BUSY
save XDUT.XSARB.OVF
save XDUT.XSARA.RAW\<0\>
save XDUT.XSARA.RAW\<1\>
save XDUT.XSARA.RAW\<2\>
save XDUT.XSARA.RAW\<3\>
save XDUT.XSARA.RAW\<4\>
save XDUT.XSARA.RAW\<5\>
save XDUT.XSARA.RAW\<6\>
save XDUT.XSARA.RAW\<7\>
save XDUT.XSARA.RAW\<8\>
save XDUT.XSARA.RAW\<9\>
save XDUT.XSARB.RAW\<0\>
save XDUT.XSARB.RAW\<1\>
save XDUT.XSARB.RAW\<2\>
save XDUT.XSARB.RAW\<3\>
save XDUT.XSARB.RAW\<4\>
save XDUT.XSARB.RAW\<5\>
save XDUT.XSARB.RAW\<6\>
save XDUT.XSARB.RAW\<7\>
save XDUT.XSARB.RAW\<8\>
save XDUT.XSARB.RAW\<9\>
save BIN\<0\>
save BIN\<1\>
save BIN\<2\>
save BIN\<3\>
save XDUT.XSARA.TOPPB
save XDUT.XSARA.TOPNB
save XDUT.XSARB.TOPPB
save XDUT.XSARB.TOPNB
save XDUT.XRA.BDP
save XDUT.XRA.BDN
save XDUT.XRA.XN
save XDUT.XRA.XP
save XDUT.XRA.BP\<0\>
save XDUT.XRA.BP\<1\>
save XDUT.XRA.BP\<2\>
save XDUT.XRA.BP\<3\>
save XDUT.XRA.BN\<0\>
save XDUT.XRA.BN\<1\>
save XDUT.XRA.BN\<2\>
save XDUT.XRA.BN\<3\>
save XDUT.XRA.H\<0\>
save XDUT.XRA.H\<1\>
save XDUT.XRA.H\<2\>
save XDUT.XRA.H\<3\>
save XDUT.XRA.HB\<0\>
save XDUT.XRA.HB\<1\>
save XDUT.XRA.HB\<2\>
save XDUT.XRA.HB\<3\>
save XDUT.XRA.L\<0\>
save XDUT.XRA.L\<1\>
save XDUT.XRA.L\<2\>
save XDUT.XRA.L\<3\>
save XDUT.XRA.LB\<0\>
save XDUT.XRA.LB\<1\>
save XDUT.XRA.LB\<2\>
save XDUT.XRA.LB\<3\>
save VDD0:p
