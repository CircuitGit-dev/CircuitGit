simulator lang=spectre
mdacArrayOptions options discontinuity=robust
