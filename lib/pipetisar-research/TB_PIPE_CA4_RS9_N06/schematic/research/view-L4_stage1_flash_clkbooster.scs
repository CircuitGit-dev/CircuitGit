// Explicit saved-library assembly.
simulator lang=spectre
include "L4_stage1_flash_clkbooster.scs"
