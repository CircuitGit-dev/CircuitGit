// Explicit saved-library assembly.
simulator lang=spectre
include "Switch.scs"
include "MDAC4_MOM_BIT_N06.scs"
include "MDAC4_REF_CTRL_N06.scs"
include "PIPE_OTA_Diff_Ideal.scs"
include "MDAC4_ARRAY_G8_N06.scs"
include "RS9_L5_9bit_Bootstrap.scs"
include "RS9_L5_9bit_Comparator_LN.scs"
include "RS9_L6_SR_latch_1.scs"
include "RS9_L6_9bit_REF_Logic.scs"
include "RS9_L5_9bit_SAR_Logic_1.scs"
include "RS9_L8_9bit_CDAC_UNIT.scs"
include "RS9_L7_9bit_CDAC.scs"
include "RS9_L6_9bit_RSW.scs"
include "RS9_L5_9bit_RSW_CDAC.scs"
include "RS9_L3_9bit_SAR_2.scs"
include "PIPE_SAR9_Real_N06.scs"
include "L4_stage1_flash_comparator.scs"
include "L4_stage1_flash_bootstrapper.scs"
include "L4_stage1_flash_clkbooster.scs"
include "L4_stage1_flash4_encoder.scs"
include "L4_stage1_flash4_rdac_FS2.scs"
include "L3_stage1_flash4_FS2.scs"
include "PIPE_TOP_CA4_RS9_N06.scs"
