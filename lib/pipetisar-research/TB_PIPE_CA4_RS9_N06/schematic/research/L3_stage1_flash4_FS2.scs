// @RNL(type="header") {
// @VERSION("0.3");
// @USE-PACKAGE(name="rnl-std-spectre", version="0.3", path="rnl-std-spectre.rnl");
// @USE-PACKAGE(name="eda-symbol", version="0.1", path="eda-symbol.rnl");
// @USE-PACKAGE(name="eda-style", version="0.1", path="eda-style.rnl")
// }
// Design: 2026_PIPETISAR_RESEARCH/L3_stage1_flash4_FS2
simulator lang=spectre
global 0

// tcbn28hpcplusbwp12t30p140ulvt/ND2D0BWP12T30P140ULVT/schematic

// tsmcN28/trans_ulvt_mac/schematic

// 2026_PIPETISAR_RESEARCH/L4_stage1_flash_comparator/schematic

// 2026_PIPETISAR_RESEARCH/L4_stage1_flash_bootstrapper/schematic

// 2026_PIPETISAR_RESEARCH/L4_stage1_flash_clkbooster/schematic

// 2026_PIPETISAR_RESEARCH/L4_stage1_flash4_encoder/schematic

// 2026_PIPETISAR_RESEARCH/L4_stage1_flash4_rdac_FS2/schematic

// 2026_PIPETISAR_RESEARCH/L3_stage1_flash4_FS2/schematic
subckt L3_stage1_flash4_FS2 BIN_3 BIN_2 BIN_1 BIN_0 D_14 D_13 D_12 D_11 D_10 D_9 D_8 D_7 D_6 D_5 D_4 D_3 D_2 D_1 D_0 DN_14 DN_13 DN_12 DN_11 DN_10 DN_9 DN_8 DN_7 DN_6 DN_5 DN_4 DN_3 DN_2 DN_1 DN_0 DP_14 DP_13 DP_12 DP_11 DP_10 DP_9 DP_8 DP_7 DP_6 DP_5 DP_4 DP_3 DP_2 DP_1 DP_0 IB_A IB_B PHI1EN PHI1N PHI2N PHI2P VCM VDD VINN VINP VOSN_14 VOSN_13 VOSN_12 VOSN_11 VOSN_10 VOSN_9 VOSN_8 VOSN_7 VOSN_6 VOSN_5 VOSN_4 VOSN_3 VOSN_2 VOSN_1 VOSN_0 VOSP_14 VOSP_13 VOSP_12 VOSP_11 VOSP_10 VOSP_9 VOSP_8 VOSP_7 VOSP_6 VOSP_5 VOSP_4 VOSP_3 VOSP_2 VOSP_1 VOSP_0 VREFN VREFP VSS
    XCB_14 (D_14 DN_14 DP_14 PHI1BSTN_B PHI1BSTP_B PHI1EN_B PHI1EP_B PHI1EPBST_B PHI2N PHI2P IB_B VCM VDD VINN VINP VOSN_14 VOSP_14 VREF_0 VREF_14 VSS) L4_stage1_flash_comparator
    XCB_13 (D_13 DN_13 DP_13 PHI1BSTN_B PHI1BSTP_B PHI1EN_B PHI1EP_B PHI1EPBST_B PHI2N PHI2P IB_B VCM VDD VINN VINP VOSN_13 VOSP_13 VREF_1 VREF_13 VSS) L4_stage1_flash_comparator
    XCB_12 (D_12 DN_12 DP_12 PHI1BSTN_B PHI1BSTP_B PHI1EN_B PHI1EP_B PHI1EPBST_B PHI2N PHI2P IB_B VCM VDD VINN VINP VOSN_12 VOSP_12 VREF_2 VREF_12 VSS) L4_stage1_flash_comparator
    XCB_11 (D_11 DN_11 DP_11 PHI1BSTN_B PHI1BSTP_B PHI1EN_B PHI1EP_B PHI1EPBST_B PHI2N PHI2P IB_B VCM VDD VINN VINP VOSN_11 VOSP_11 VREF_3 VREF_11 VSS) L4_stage1_flash_comparator
    XCB_10 (D_10 DN_10 DP_10 PHI1BSTN_B PHI1BSTP_B PHI1EN_B PHI1EP_B PHI1EPBST_B PHI2N PHI2P IB_B VCM VDD VINN VINP VOSN_10 VOSP_10 VREF_4 VREF_10 VSS) L4_stage1_flash_comparator
    XCB_9 (D_9 DN_9 DP_9 PHI1BSTN_B PHI1BSTP_B PHI1EN_B PHI1EP_B PHI1EPBST_B PHI2N PHI2P IB_B VCM VDD VINN VINP VOSN_9 VOSP_9 VREF_5 VREF_9 VSS) L4_stage1_flash_comparator
    XCB_8 (D_8 DN_8 DP_8 PHI1BSTN_B PHI1BSTP_B PHI1EN_B PHI1EP_B PHI1EPBST_B PHI2N PHI2P IB_B VCM VDD VINN VINP VOSN_8 VOSP_8 VREF_6 VREF_8 VSS) L4_stage1_flash_comparator
    XCA_7 (D_7 DN_7 DP_7 PHI1BSTN_A PHI1BSTP_A PHI1EN_A PHI1EP_A PHI1EPBST_A PHI2N PHI2P IB_A VCM VDD VINN VINP VOSN_7 VOSP_7 VREF_7 VREF_7 VSS) L4_stage1_flash_comparator
    XCA_6 (D_6 DN_6 DP_6 PHI1BSTN_A PHI1BSTP_A PHI1EN_A PHI1EP_A PHI1EPBST_A PHI2N PHI2P IB_A VCM VDD VINN VINP VOSN_6 VOSP_6 VREF_8 VREF_6 VSS) L4_stage1_flash_comparator
    XCA_5 (D_5 DN_5 DP_5 PHI1BSTN_A PHI1BSTP_A PHI1EN_A PHI1EP_A PHI1EPBST_A PHI2N PHI2P IB_A VCM VDD VINN VINP VOSN_5 VOSP_5 VREF_9 VREF_5 VSS) L4_stage1_flash_comparator
    XCA_4 (D_4 DN_4 DP_4 PHI1BSTN_A PHI1BSTP_A PHI1EN_A PHI1EP_A PHI1EPBST_A PHI2N PHI2P IB_A VCM VDD VINN VINP VOSN_4 VOSP_4 VREF_10 VREF_4 VSS) L4_stage1_flash_comparator
    XCA_3 (D_3 DN_3 DP_3 PHI1BSTN_A PHI1BSTP_A PHI1EN_A PHI1EP_A PHI1EPBST_A PHI2N PHI2P IB_A VCM VDD VINN VINP VOSN_3 VOSP_3 VREF_11 VREF_3 VSS) L4_stage1_flash_comparator
    XCA_2 (D_2 DN_2 DP_2 PHI1BSTN_A PHI1BSTP_A PHI1EN_A PHI1EP_A PHI1EPBST_A PHI2N PHI2P IB_A VCM VDD VINN VINP VOSN_2 VOSP_2 VREF_12 VREF_2 VSS) L4_stage1_flash_comparator
    XCA_1 (D_1 DN_1 DP_1 PHI1BSTN_A PHI1BSTP_A PHI1EN_A PHI1EP_A PHI1EPBST_A PHI2N PHI2P IB_A VCM VDD VINN VINP VOSN_1 VOSP_1 VREF_13 VREF_1 VSS) L4_stage1_flash_comparator
    XCA_0 (D_0 DN_0 DP_0 PHI1BSTN_A PHI1BSTP_A PHI1EN_A PHI1EP_A PHI1EPBST_A PHI2N PHI2P IB_A VCM VDD VINN VINP VOSN_0 VOSP_0 VREF_14 VREF_0 VSS) L4_stage1_flash_comparator
    XBOOT_B (PHI1N PHI1BSTN_B PHI1BSTP_B VDD VINN VINP VSS) L4_stage1_flash_bootstrapper
    XBOOT_A (PHI1N PHI1BSTN_A PHI1BSTP_A VDD VINN VINP VSS) L4_stage1_flash_bootstrapper
    XCLK_B (PHI1EN PHI1EN_B PHI1EPBST_B PHI1EP_B VDD VSS) L4_stage1_flash_clkbooster
    XCLK_A (PHI1EN PHI1EN_A PHI1EPBST_A PHI1EP_A VDD VSS) L4_stage1_flash_clkbooster
    M0_B (IB_B VCM BIAS_INT_B VSS) nch_ulvt_mac l=30n w=9u multi=1 nf=18
    M0_A (IB_A VCM BIAS_INT_A VSS) nch_ulvt_mac l=30n w=9u multi=1 nf=18
    M1_B (VSS IB_B VSS VSS) nch_mac l=90n w=500n multi=2 nf=1
    M24_B (BIAS_INT_B IB_B VSS VSS) nch_mac l=90n w=500n multi=8 nf=1
    M1_A (VSS IB_A VSS VSS) nch_mac l=90n w=500n multi=2 nf=1
    M24_A (BIAS_INT_A IB_A VSS VSS) nch_mac l=90n w=500n multi=8 nf=1
    C0_B (IB_B VSS) cfmom_2t nr=24 lr=2u w=50n s=50n stm=1 spm=7 multi=1
    C0_A (IB_A VSS) cfmom_2t nr=24 lr=2u w=50n s=50n stm=1 spm=7 multi=1
    XENC (BIN_3 BIN_2 BIN_1 BIN_0 D_14 D_13 D_12 D_11 D_10 D_9 D_8 D_7 D_6 D_5 D_4 D_3 D_2 D_1 D_0 VDD VSS) L4_stage1_flash4_encoder
    XRDAC (VREF_14 VREF_13 VREF_12 VREF_11 VREF_10 VREF_9 VREF_8 VREF_7 VREF_6 VREF_5 VREF_4 VREF_3 VREF_2 VREF_1 VREF_0 VREFN VREFP) L4_stage1_flash4_rdac_FS2
// @RNL(author="rnl-virtuoso") {
// %block_symbol = @DEFINE-SYMBOL(box=[0, -120, 70.4, 4.8]) {
// @RECTANGLE {(0, -120) (70.4, 4.8)};
// (35.2, 10.4) @TEXT("4b FLASH", size=4.6, halign="middle", valign="middle");
// ? @TEXT("${name}", size=3.8, halign="middle", valign="middle", key="name") => @PLACE(35.2, -125.1);
// (70.4, -107.2) @PIN(terminal="IB_B");
// (68.2, -107.2) @TEXT("IB\_B", size=3.8, halign="end", valign="middle");
// (70.4, -97.6) @PIN(terminal="IB_A");
// (68.2, -97.6) @TEXT("IB\_A", size=3.8, halign="end", valign="middle");
// (70.4, -86.4) @PIN(terminal=["VOSN_14", "VOSN_13", "VOSN_12", "VOSN_11", "VOSN_10", "VOSN_9", "VOSN_8", "VOSN_7", "VOSN_6", "VOSN_5", "VOSN_4", "VOSN_3", "VOSN_2", "VOSN_1", "VOSN_0"]);
// (68.2, -86.4) @TEXT("VOSN<14:0>", size=3.8, halign="end", valign="middle");
// (70.4, -78.4) @PIN(terminal=["VOSP_14", "VOSP_13", "VOSP_12", "VOSP_11", "VOSP_10", "VOSP_9", "VOSP_8", "VOSP_7", "VOSP_6", "VOSP_5", "VOSP_4", "VOSP_3", "VOSP_2", "VOSP_1", "VOSP_0"]);
// (68.2, -78.4) @TEXT("VOSP<14:0>", size=3.8, halign="end", valign="middle");
// (70.4, -67.2) @PIN(terminal=["DN_14", "DN_13", "DN_12", "DN_11", "DN_10", "DN_9", "DN_8", "DN_7", "DN_6", "DN_5", "DN_4", "DN_3", "DN_2", "DN_1", "DN_0"]);
// (68.2, -67.2) @TEXT("DN<14:0>", size=3.8, halign="end", valign="middle");
// (70.4, -51.2) @PIN(terminal=["BIN_3", "BIN_2", "BIN_1", "BIN_0"]);
// (68.2, -51.2) @TEXT("BIN<3:0>", size=3.8, halign="end", valign="middle");
// (70.4, -59.2) @PIN(terminal=["DP_14", "DP_13", "DP_12", "DP_11", "DP_10", "DP_9", "DP_8", "DP_7", "DP_6", "DP_5", "DP_4", "DP_3", "DP_2", "DP_1", "DP_0"]);
// (68.2, -59.2) @TEXT("DP<14:0>", size=3.8, halign="end", valign="middle");
// (0, -28.8) @PIN(terminal="PHI1EN");
// (2.2, -28.8) @TEXT("PHI1EN", size=3.8, halign="start", valign="middle");
// (0, -36.8) @PIN(terminal="PHI1N");
// (2.2, -36.8) @TEXT("PHI1N", size=3.8, halign="start", valign="middle");
// (0, -44.8) @PIN(terminal="PHI2P");
// (2.2, -44.8) @TEXT("PHI2P", size=3.8, halign="start", valign="middle");
// (0, -52.8) @PIN(terminal="PHI2N");
// (2.2, -52.8) @TEXT("PHI2N", size=3.8, halign="start", valign="middle");
// (0, -83.2) @PIN(terminal="VREFP");
// (2.2, -83.2) @TEXT("VREFP", size=3.8, halign="start", valign="middle");
// (0, -91.2) @PIN(terminal="VREFN");
// (2.2, -91.2) @TEXT("VREFN", size=3.8, halign="start", valign="middle");
// (0, -99.2) @PIN(terminal="VCM");
// (2.2, -99.2) @TEXT("VCM", size=3.8, halign="start", valign="middle");
// (0, -107.2) @PIN(terminal="VDD");
// (2.2, -107.2) @TEXT("VDD", size=3.8, halign="start", valign="middle");
// (0, -115.2) @PIN(terminal="VSS");
// (2.2, -115.2) @TEXT("VSS", size=3.8, halign="start", valign="middle");
// (70.4, 0) @PIN(terminal=["D_14", "D_13", "D_12", "D_11", "D_10", "D_9", "D_8", "D_7", "D_6", "D_5", "D_4", "D_3", "D_2", "D_1", "D_0"]);
// (68.2, 0) @TEXT("D<14:0>", size=3.8, halign="end", valign="middle");
// (0, -12.8) @PIN(terminal="VINN");
// (2.2, -12.8) @TEXT("VINN", size=3.8, halign="start", valign="middle");
// (0, 0) @PIN(terminal="VINP");
// (2.2, 0) @TEXT("VINP", size=3.8, halign="start", valign="middle")
// };
// # @SET-SYMBOL %block_symbol;
// #"XBOOT_A" @PLACE(155, 54) => @ORIENT("R0");
// %symbol_0 = @DEFINE-SYMBOL(box=[-0.1, -2.8, 3.8, 2.8]) {
// @LINE {(2, 1.5) (4, 1.5) (4, 3)};
// @LINE {(2, -1.5) (2, 1.5)};
// @LINE {(3, -1) (4, -1.5) (3, -2)};
// @LINE {(0, 0) (1.5, 0)};
// @LINE {(1.5, 1.5) (1.5, -1.5)};
// @LINE {(2, -1.5) (4, -1.5) (4, -3)};
// ? @TEXT("${name}", size=0.8, halign="start", valign="baseline", key="name") => @PLACE(5, 3.5);
// ? @TEXT("${model}", size=0.8, halign="end", valign="baseline", key="model") => @PLACE(3.2, 3.2);
// (4, -1) @PIN(terminal=4);
// (4, -3) @PIN(terminal=3);
// (4, 3) @PIN(terminal=1);
// (0, 0) @PIN(terminal=2)
// };
// #"M1_B" @SET-SYMBOL %symbol_0;
// #"M1_B" @PLACE(298, -39) => @ORIENT("MYR90");
// %bundle_0 = {#"XCB_14" #"XCB_13" #"XCB_12" #"XCB_11" #"XCB_10" #"XCB_9" #"XCB_8"} @BUNDLE;
// %bundle_0 @PLACE(256, 0) => @ORIENT("R0");
// %bundle_0 @TEXT("XCB<14:8>", key="name");
// #"M24_B" @SET-SYMBOL %symbol_0;
// #"M24_B" @PLACE(277, -39) => @ORIENT("MY");
// #"XENC" @PLACE(305, 0) => @ORIENT("R0");
// %bundle_1 = {#"XCA_7" #"XCA_6" #"XCA_5" #"XCA_4" #"XCA_3" #"XCA_2" #"XCA_1" #"XCA_0"} @BUNDLE;
// %bundle_1 @PLACE(180, 3) => @ORIENT("R0");
// %bundle_1 @TEXT("XCA<7:0>", key="name");
// #"M24_A" @SET-SYMBOL %symbol_0;
// #"M24_A" @PLACE(192, -38) => @ORIENT("MY");
// #"M1_A" @SET-SYMBOL %symbol_0;
// #"M1_A" @PLACE(212, -37) => @ORIENT("MYR90");
// %symbol_1 = @DEFINE-SYMBOL(box=[-0.1, -2.8, 3.8, 2.8]) {
// @LINE {(2, 1.5) (4, 1.5) (4, 3)};
// @LINE {(2, -1.5) (2, 1.5)};
// @LINE {(3, -1) (4, -1.5) (3, -2)};
// @LINE {(0, 0) (1.5, 0)};
// @LINE {(1.5, 1.5) (1.5, -1.5)};
// @LINE {(2, -1.5) (4, -1.5) (4, -3)};
// ? @TEXT("${name}", size=0.8, halign="start", valign="baseline", key="name") => @PLACE(5, 3.5);
// ? @TEXT("${model}", size=0.8, halign="end", valign="baseline", key="model") => @PLACE(3.2, 3.2);
// (4, -1) @PIN(terminal=4);
// (4, -3) @PIN(terminal=3);
// (4, 3) @PIN(terminal=1);
// (0, 0) @PIN(terminal=2)
// };
// #"M0_B" @SET-SYMBOL %symbol_1;
// #"M0_B" @PLACE(250, -39) => @ORIENT("R0");
// #"XBOOT_B" @PLACE(256, 55) => @ORIENT("R0");
// #"XRDAC" @PLACE(119, -31) => @ORIENT("R0");
// #"M0_A" @SET-SYMBOL %symbol_1;
// #"M0_A" @PLACE(163, -38) => @ORIENT("R0");
// %symbol_2 = @DEFINE-SYMBOL(box=[-2, -6, 2, 0]) {
// @LINE {(1, -2.2) (-1, -2.2)};
// @LINE {(0, 0) (0, -2.2)};
// @LINE {(0, -2.8) (0, -6)};
// @ARC {(1, -3.2) (0, -2.8) (-1, -3.2)};
// ? @TEXT("${name}", size=0.8, halign="start", valign="baseline", key="name") => @PLACE(1.4, 0.1);
// ? @TEXT("${model}", size=0.8, halign="end", valign="baseline", key="model") => @PLACE(-1.1, 0.3);
// (0, 0) @PIN(terminal=1);
// (0, -6) @PIN(terminal=2)
// };
// #"C0_B" @SET-SYMBOL %symbol_2;
// #"C0_B" @PLACE(317, -38) => @ORIENT("R0");
// #"C0_A" @SET-SYMBOL %symbol_2;
// #"C0_A" @PLACE(231, -37) => @ORIENT("R0");
// #"XCLK_B" @PLACE(304, 56) => @ORIENT("R0");
// #"XCLK_A" @PLACE(202, 55) => @ORIENT("R0");
// %input_port_symbol = @DEFINE-SYMBOL(box=[-2, -1, 0, 1]) {
// @LINE(fill="linecolor", linestyle="none") {(-2, -0.9) (-2, 0.9) (-0.9, 0.9) (0, 0) (-0.9, -0.9) (-2, -0.9)};
// (0, 0) @PIN(terminal=1, direction="right");
// ? @TEXT("${name}", key="name", halign="middle") => @PLACE(-1, 1.6)
// };
// %port_0 = $IO_PORT @ATTACH &"VINP" => @PLACE(79, 83) => @ORIENT("R0");
// %port_0 @SET-SYMBOL %input_port_symbol;
// %port_0 @TEXT("VINP", key="name");
// %port_1 = $IO_PORT @ATTACH &"VINN" => @PLACE(79, 75) => @ORIENT("R0");
// %port_1 @SET-SYMBOL %input_port_symbol;
// %port_1 @TEXT("VINN", key="name");
// %port_2 = $IO_PORT @ATTACH &"PHI1EN" => @PLACE(79, 67) => @ORIENT("R0");
// %port_2 @SET-SYMBOL %input_port_symbol;
// %port_2 @TEXT("PHI1EN", key="name");
// %port_3 = $IO_PORT @ATTACH &"PHI1N" => @PLACE(79, 59) => @ORIENT("R0");
// %port_3 @SET-SYMBOL %input_port_symbol;
// %port_3 @TEXT("PHI1N", key="name");
// %port_4 = $IO_PORT @ATTACH &"PHI2P" => @PLACE(79, 51) => @ORIENT("R0");
// %port_4 @SET-SYMBOL %input_port_symbol;
// %port_4 @TEXT("PHI2P", key="name");
// %port_5 = $IO_PORT @ATTACH &"PHI2N" => @PLACE(79, 43) => @ORIENT("R0");
// %port_5 @SET-SYMBOL %input_port_symbol;
// %port_5 @TEXT("PHI2N", key="name");
// %bus_port_type_6 = @DEFINE(roles=[["p", "net"], ["p1", "net"], ["p2", "net"], ["p3", "net"], ["p4", "net"], ["p5", "net"], ["p6", "net"], ["p7", "net"], ["p8", "net"], ["p9", "net"], ["p10", "net"], ["p11", "net"], ["p12", "net"], ["p13", "net"], ["p14", "net"]]) {};
// %bus_port_type_6_symbol = @DEFINE-SYMBOL {(0, 0) @PIN(terminal=[1, 2, 3, 4, 5, 6, 7, 8, 9, 10, 11, 12, 13, 14, 15])};
// {&"VOSP_14" &"VOSP_13" &"VOSP_12" &"VOSP_11" &"VOSP_10" &"VOSP_9" &"VOSP_8" &"VOSP_7" &"VOSP_6" &"VOSP_5" &"VOSP_4" &"VOSP_3" &"VOSP_2" &"VOSP_1" &"VOSP_0"} @REMOVE-FROM $PORT_FILL_SET;
// %port_6 = %bus_port_type_6 @ATTACH &"VOSP_14" &"VOSP_13" &"VOSP_12" &"VOSP_11" &"VOSP_10" &"VOSP_9" &"VOSP_8" &"VOSP_7" &"VOSP_6" &"VOSP_5" &"VOSP_4" &"VOSP_3" &"VOSP_2" &"VOSP_1" &"VOSP_0" => @PLACE(79, 35) => @ORIENT("R0");
// %port_6 @SET-SYMBOL %bus_port_type_6_symbol;
// %port_6_marker = $IO_PORT @ATTACH &"VOSP_14" => @PLACE(79, 35) => @ORIENT("R0");
// %port_6_marker @SET-SYMBOL %input_port_symbol;
// %port_6_marker @TEXT("VOSP<14:0>", key="name");
// %bus_port_type_7 = @DEFINE(roles=[["p", "net"], ["p1", "net"], ["p2", "net"], ["p3", "net"], ["p4", "net"], ["p5", "net"], ["p6", "net"], ["p7", "net"], ["p8", "net"], ["p9", "net"], ["p10", "net"], ["p11", "net"], ["p12", "net"], ["p13", "net"], ["p14", "net"]]) {};
// %bus_port_type_7_symbol = @DEFINE-SYMBOL {(0, 0) @PIN(terminal=[1, 2, 3, 4, 5, 6, 7, 8, 9, 10, 11, 12, 13, 14, 15])};
// {&"VOSN_14" &"VOSN_13" &"VOSN_12" &"VOSN_11" &"VOSN_10" &"VOSN_9" &"VOSN_8" &"VOSN_7" &"VOSN_6" &"VOSN_5" &"VOSN_4" &"VOSN_3" &"VOSN_2" &"VOSN_1" &"VOSN_0"} @REMOVE-FROM $PORT_FILL_SET;
// %port_7 = %bus_port_type_7 @ATTACH &"VOSN_14" &"VOSN_13" &"VOSN_12" &"VOSN_11" &"VOSN_10" &"VOSN_9" &"VOSN_8" &"VOSN_7" &"VOSN_6" &"VOSN_5" &"VOSN_4" &"VOSN_3" &"VOSN_2" &"VOSN_1" &"VOSN_0" => @PLACE(79, 27) => @ORIENT("R0");
// %port_7 @SET-SYMBOL %bus_port_type_7_symbol;
// %port_7_marker = $IO_PORT @ATTACH &"VOSN_14" => @PLACE(79, 27) => @ORIENT("R0");
// %port_7_marker @SET-SYMBOL %input_port_symbol;
// %port_7_marker @TEXT("VOSN<14:0>", key="name");
// %port_8 = $IO_PORT @ATTACH &"VDD" => @PLACE(79, 19) => @ORIENT("R0");
// %port_9 = $IO_PORT @ATTACH &"VSS" => @PLACE(79, 11) => @ORIENT("R0");
// %port_10 = $IO_PORT @ATTACH &"VCM" => @PLACE(79, 3) => @ORIENT("R0");
// %port_11 = $IO_PORT @ATTACH &"VREFP" => @PLACE(79, -5) => @ORIENT("R0");
// %port_12 = $IO_PORT @ATTACH &"VREFN" => @PLACE(79, -13) => @ORIENT("R0");
// %port_13 = $IO_PORT @ATTACH &"IB_A" => @PLACE(79, -21) => @ORIENT("R0");
// %port_14 = $IO_PORT @ATTACH &"IB_B" => @PLACE(79, -29) => @ORIENT("R0");
// %output_port_symbol = @DEFINE-SYMBOL(box=[0, -1, 2, 1]) {
// @LINE(fill="linecolor", linestyle="none") {(0, -0.9) (0, 0.9) (1.1, 0.9) (2, 0) (1.1, -0.9) (0, -0.9)};
// (0, 0) @PIN(terminal=1, direction="left");
// ? @TEXT("${name}", key="name", halign="middle") => @PLACE(1, 1.6)
// };
// %bus_port_type_15 = @DEFINE(roles=[["p", "net"], ["p1", "net"], ["p2", "net"], ["p3", "net"], ["p4", "net"], ["p5", "net"], ["p6", "net"], ["p7", "net"], ["p8", "net"], ["p9", "net"], ["p10", "net"], ["p11", "net"], ["p12", "net"], ["p13", "net"], ["p14", "net"]]) {};
// %bus_port_type_15_symbol = @DEFINE-SYMBOL {(0, 0) @PIN(terminal=[1, 2, 3, 4, 5, 6, 7, 8, 9, 10, 11, 12, 13, 14, 15])};
// {&"D_14" &"D_13" &"D_12" &"D_11" &"D_10" &"D_9" &"D_8" &"D_7" &"D_6" &"D_5" &"D_4" &"D_3" &"D_2" &"D_1" &"D_0"} @REMOVE-FROM $PORT_FILL_SET;
// %port_15 = %bus_port_type_15 @ATTACH &"D_14" &"D_13" &"D_12" &"D_11" &"D_10" &"D_9" &"D_8" &"D_7" &"D_6" &"D_5" &"D_4" &"D_3" &"D_2" &"D_1" &"D_0" => @PLACE(79, -37) => @ORIENT("R0");
// %port_15 @SET-SYMBOL %bus_port_type_15_symbol;
// %port_15_marker = $IO_PORT @ATTACH &"D_14" => @PLACE(79, -37) => @ORIENT("R0");
// %port_15_marker @SET-SYMBOL %output_port_symbol;
// %port_15_marker @TEXT("D<14:0>", key="name");
// %bus_port_type_16 = @DEFINE(roles=[["p", "net"], ["p1", "net"], ["p2", "net"], ["p3", "net"], ["p4", "net"], ["p5", "net"], ["p6", "net"], ["p7", "net"], ["p8", "net"], ["p9", "net"], ["p10", "net"], ["p11", "net"], ["p12", "net"], ["p13", "net"], ["p14", "net"]]) {};
// %bus_port_type_16_symbol = @DEFINE-SYMBOL {(0, 0) @PIN(terminal=[1, 2, 3, 4, 5, 6, 7, 8, 9, 10, 11, 12, 13, 14, 15])};
// {&"DP_14" &"DP_13" &"DP_12" &"DP_11" &"DP_10" &"DP_9" &"DP_8" &"DP_7" &"DP_6" &"DP_5" &"DP_4" &"DP_3" &"DP_2" &"DP_1" &"DP_0"} @REMOVE-FROM $PORT_FILL_SET;
// %port_16 = %bus_port_type_16 @ATTACH &"DP_14" &"DP_13" &"DP_12" &"DP_11" &"DP_10" &"DP_9" &"DP_8" &"DP_7" &"DP_6" &"DP_5" &"DP_4" &"DP_3" &"DP_2" &"DP_1" &"DP_0" => @PLACE(79, -45) => @ORIENT("R0");
// %port_16 @SET-SYMBOL %bus_port_type_16_symbol;
// %port_16_marker = $IO_PORT @ATTACH &"DP_14" => @PLACE(79, -45) => @ORIENT("R0");
// %port_16_marker @SET-SYMBOL %output_port_symbol;
// %port_16_marker @TEXT("DP<14:0>", key="name");
// %bus_port_type_17 = @DEFINE(roles=[["p", "net"], ["p1", "net"], ["p2", "net"], ["p3", "net"], ["p4", "net"], ["p5", "net"], ["p6", "net"], ["p7", "net"], ["p8", "net"], ["p9", "net"], ["p10", "net"], ["p11", "net"], ["p12", "net"], ["p13", "net"], ["p14", "net"]]) {};
// %bus_port_type_17_symbol = @DEFINE-SYMBOL {(0, 0) @PIN(terminal=[1, 2, 3, 4, 5, 6, 7, 8, 9, 10, 11, 12, 13, 14, 15])};
// {&"DN_14" &"DN_13" &"DN_12" &"DN_11" &"DN_10" &"DN_9" &"DN_8" &"DN_7" &"DN_6" &"DN_5" &"DN_4" &"DN_3" &"DN_2" &"DN_1" &"DN_0"} @REMOVE-FROM $PORT_FILL_SET;
// %port_17 = %bus_port_type_17 @ATTACH &"DN_14" &"DN_13" &"DN_12" &"DN_11" &"DN_10" &"DN_9" &"DN_8" &"DN_7" &"DN_6" &"DN_5" &"DN_4" &"DN_3" &"DN_2" &"DN_1" &"DN_0" => @PLACE(79, -53) => @ORIENT("R0");
// %port_17 @SET-SYMBOL %bus_port_type_17_symbol;
// %port_17_marker = $IO_PORT @ATTACH &"DN_14" => @PLACE(79, -53) => @ORIENT("R0");
// %port_17_marker @SET-SYMBOL %output_port_symbol;
// %port_17_marker @TEXT("DN<14:0>", key="name");
// %bus_port_type_18 = @DEFINE(roles=[["p", "net"], ["p1", "net"], ["p2", "net"], ["p3", "net"]]) {};
// %bus_port_type_18_symbol = @DEFINE-SYMBOL {(0, 0) @PIN(terminal=[1, 2, 3, 4])};
// {&"BIN_3" &"BIN_2" &"BIN_1" &"BIN_0"} @REMOVE-FROM $PORT_FILL_SET;
// %port_18 = %bus_port_type_18 @ATTACH &"BIN_3" &"BIN_2" &"BIN_1" &"BIN_0" => @PLACE(358, 1) => @ORIENT("R0");
// %port_18 @SET-SYMBOL %bus_port_type_18_symbol;
// %port_18_marker = $IO_PORT @ATTACH &"BIN_3" => @PLACE(358, 1) => @ORIENT("R0");
// %port_18_marker @SET-SYMBOL %output_port_symbol;
// %port_18_marker @TEXT("BIN<3:0>", key="name");
// %p0 = (364.4, 1);
// %wire_0 = {&"BIN_3" &"BIN_2" &"BIN_1" &"BIN_0"} @WIRE(mode="straight") {%port_18:1 %p0};
// %p1 = (349, 0);
// %wire_1 = {&"BIN_3" &"BIN_2" &"BIN_1" &"BIN_0"} @WIRE(mode="straight") {#"XENC":1 %p1};
// %wire_1 @TEXT("BIN<3:0>", size=1, halign="middle", valign="baseline") => @PLACE(345, 0);
// %wire_0 @TEXT("BIN<3:0>", size=1, halign="middle", valign="middle") => @PLACE(361.2, 1);
// %p2 = (273, -28);
// %wire_2 = &"BIAS_INT_B" @WIRE(mode="straight") {#"M24_B":1 %p2};
// %p3 = (254, -50);
// %wire_3 = &"BIAS_INT_B" @WIRE(mode="straight") {%p3 #"M0_B":3};
// %wire_3 @TEXT("BIAS\_INT\_B", size=1, halign="middle", valign="baseline") => @PLACE(254, -46);
// %wire_2 @TEXT("BIAS\_INT\_B", size=1, halign="middle", valign="baseline") => @PLACE(273, -32);
// %p4 = (188, -27);
// %wire_4 = &"BIAS_INT_A" @WIRE(mode="straight") {#"M24_A":1 %p4};
// %p5 = (167, -49);
// %wire_5 = &"BIAS_INT_A" @WIRE(mode="straight") {%p5 #"M0_A":3};
// %wire_5 @TEXT("BIAS\_INT\_A", size=1, halign="middle", valign="baseline") => @PLACE(167, -45);
// %wire_4 @TEXT("BIAS\_INT\_A", size=1, halign="middle", valign="baseline") => @PLACE(188, -31);
// %p6 = (253, -20);
// %wire_6 = {&"VREF_14" &"VREF_13" &"VREF_12" &"VREF_11" &"VREF_10" &"VREF_9" &"VREF_8"} @WIRE(mode="straight") {%p6 %bundle_0:19};
// %wire_6 @TEXT("VREF<14:8>", size=1, halign="middle", valign="baseline") => @PLACE(253, -16);
// %p7 = (255, -20);
// %wire_7 = {&"VREF_0" &"VREF_1" &"VREF_2" &"VREF_3" &"VREF_4" &"VREF_5" &"VREF_6"} @WIRE(mode="straight") {%p7 %bundle_0:18};
// %wire_7 @TEXT("VREF<0:6>", size=1, halign="middle", valign="baseline") => @PLACE(255, -16);
// %p8 = (232, 0);
// %wire_8 = {&"VOSP_14" &"VOSP_13" &"VOSP_12" &"VOSP_11" &"VOSP_10" &"VOSP_9" &"VOSP_8"} @WIRE(mode="straight") {%p8 %bundle_0:17};
// %wire_8 @TEXT("VOSP<14:8>", size=1, halign="middle", valign="baseline") => @PLACE(236, 0);
// %p9 = (232, -2);
// %wire_9 = {&"VOSN_14" &"VOSN_13" &"VOSN_12" &"VOSN_11" &"VOSN_10" &"VOSN_9" &"VOSN_8"} @WIRE(mode="straight") {%p9 %bundle_0:16};
// %wire_9 @TEXT("VOSN<14:8>", size=1, halign="middle", valign="baseline") => @PLACE(236, -2);
// %p10 = (282, 2);
// %wire_10 = {&"DP_14" &"DP_13" &"DP_12" &"DP_11" &"DP_10" &"DP_9" &"DP_8"} @WIRE(mode="straight") {%bundle_0:3 %p10};
// %wire_10 @TEXT("DP<14:8>", size=1, halign="middle", valign="baseline") => @PLACE(278, 2);
// %p11 = (282, 0);
// %wire_11 = {&"DN_14" &"DN_13" &"DN_12" &"DN_11" &"DN_10" &"DN_9" &"DN_8"} @WIRE(mode="straight") {%bundle_0:2 %p11};
// %wire_11 @TEXT("DN<14:8>", size=1, halign="middle", valign="baseline") => @PLACE(278, 0);
// %p12 = (282, -2);
// %wire_12 = {&"D_14" &"D_13" &"D_12" &"D_11" &"D_10" &"D_9" &"D_8"} @WIRE(mode="straight") {%bundle_0:1 %p12};
// %wire_12 @TEXT("D<14:8>", size=1, halign="middle", valign="baseline") => @PLACE(278, -2);
// %p13 = (179, -17);
// %wire_13 = {&"VREF_14" &"VREF_13" &"VREF_12" &"VREF_11" &"VREF_10" &"VREF_9" &"VREF_8" &"VREF_7"} @WIRE(mode="straight") {%p13 %bundle_1:18};
// %wire_13 @TEXT("VREF<7:14>", size=1, halign="middle", valign="baseline") => @PLACE(179, -13);
// %p14 = (177, -17);
// %wire_14 = {&"VREF_0" &"VREF_1" &"VREF_2" &"VREF_3" &"VREF_4" &"VREF_5" &"VREF_6" &"VREF_7"} @WIRE(mode="straight") {%p14 %bundle_1:19};
// %wire_14 @TEXT("VREF<7:0>", size=1, halign="middle", valign="baseline") => @PLACE(177, -13);
// %p15 = (156, 3);
// %wire_15 = {&"VOSP_7" &"VOSP_6" &"VOSP_5" &"VOSP_4" &"VOSP_3" &"VOSP_2" &"VOSP_1" &"VOSP_0"} @WIRE(mode="straight") {%p15 %bundle_1:17};
// %wire_15 @TEXT("VOSP<7:0>", size=1, halign="middle", valign="baseline") => @PLACE(160, 3);
// %p16 = (156, 1);
// %wire_16 = {&"VOSN_7" &"VOSN_6" &"VOSN_5" &"VOSN_4" &"VOSN_3" &"VOSN_2" &"VOSN_1" &"VOSN_0"} @WIRE(mode="straight") {%p16 %bundle_1:16};
// %wire_16 @TEXT("VOSN<7:0>", size=1, halign="middle", valign="baseline") => @PLACE(160, 1);
// %p17 = (206, 5);
// %wire_17 = {&"DP_7" &"DP_6" &"DP_5" &"DP_4" &"DP_3" &"DP_2" &"DP_1" &"DP_0"} @WIRE(mode="straight") {%bundle_1:3 %p17};
// %wire_17 @TEXT("DP<7:0>", size=1, halign="middle", valign="baseline") => @PLACE(202, 5);
// %p18 = (206, 3);
// %wire_18 = {&"DN_7" &"DN_6" &"DN_5" &"DN_4" &"DN_3" &"DN_2" &"DN_1" &"DN_0"} @WIRE(mode="straight") {%bundle_1:2 %p18};
// %wire_18 @TEXT("DN<7:0>", size=1, halign="middle", valign="baseline") => @PLACE(202, 3);
// %p19 = (206, 1);
// %wire_19 = {&"D_7" &"D_6" &"D_5" &"D_4" &"D_3" &"D_2" &"D_1" &"D_0"} @WIRE(mode="straight") {%bundle_1:1 %p19};
// %wire_19 @TEXT("D<7:0>", size=1, halign="middle", valign="baseline") => @PLACE(202, 1);
// %p20 = (144, -40);
// %wire_20 = {&"VREF_14" &"VREF_13" &"VREF_12" &"VREF_11" &"VREF_10" &"VREF_9" &"VREF_8" &"VREF_0" &"VREF_1" &"VREF_2" &"VREF_3" &"VREF_4" &"VREF_5" &"VREF_6" &"VREF_7"} @WIRE(mode="straight") {#"XRDAC":1 %p20};
// %wire_20 @TEXT("VREF<14:0>", size=1, halign="middle", valign="baseline") => @PLACE(140, -40);
// %p21 = (259, -20);
// %wire_21 = &"VSS" @WIRE(mode="straight") {%p21 %bundle_0:20};
// %wire_21 @TEXT("<*7>VSS", size=1, halign="middle", valign="baseline") => @PLACE(259, -16);
// %p22 = (183, -17);
// %wire_22 = &"VSS" @WIRE(mode="straight") {%p22 %bundle_1:20};
// %wire_22 @TEXT("<*8>VSS", size=1, halign="middle", valign="baseline") => @PLACE(183, -13);
// %p23 = (232, 4);
// %wire_23 = &"VINP" @WIRE(mode="straight") {%p23 %bundle_0:15};
// %wire_23 @TEXT("<*7>VINP", size=1, halign="middle", valign="baseline") => @PLACE(236, 4);
// %p24 = (156, 7);
// %wire_24 = &"VINP" @WIRE(mode="straight") {%p24 %bundle_1:15};
// %wire_24 @TEXT("<*8>VINP", size=1, halign="middle", valign="baseline") => @PLACE(160, 7);
// %p25 = (232, 2);
// %wire_25 = &"VINN" @WIRE(mode="straight") {%p25 %bundle_0:14};
// %wire_25 @TEXT("<*7>VINN", size=1, halign="middle", valign="baseline") => @PLACE(236, 2);
// %p26 = (156, 5);
// %wire_26 = &"VINN" @WIRE(mode="straight") {%p26 %bundle_1:14};
// %wire_26 @TEXT("<*8>VINN", size=1, halign="middle", valign="baseline") => @PLACE(160, 5);
// %p27 = (257, -20);
// %wire_27 = &"VDD" @WIRE(mode="straight") {%p27 %bundle_0:13};
// %wire_27 @TEXT("<*7>VDD", size=1, halign="middle", valign="baseline") => @PLACE(257, -16);
// %p28 = (181, -17);
// %wire_28 = &"VDD" @WIRE(mode="straight") {%p28 %bundle_1:13};
// %wire_28 @TEXT("<*8>VDD", size=1, halign="middle", valign="baseline") => @PLACE(181, -13);
// %p29 = (250, 20);
// %wire_29 = &"VCM" @WIRE(mode="straight") {%bundle_0:12 %p29};
// %wire_29 @TEXT("<*7>VCM", size=1, halign="middle", valign="baseline") => @PLACE(250, 16);
// %p30 = (174, 23);
// %wire_30 = &"VCM" @WIRE(mode="straight") {%bundle_1:12 %p30};
// %wire_30 @TEXT("<*8>VCM", size=1, halign="middle", valign="baseline") => @PLACE(174, 19);
// %p31 = (262, 20);
// %wire_31 = &"PHI2P" @WIRE(mode="straight") {%bundle_0:10 %p31};
// %wire_31 @TEXT("<*7>PHI2P", size=1, halign="middle", valign="baseline") => @PLACE(262, 16);
// %p32 = (186, 23);
// %wire_32 = &"PHI2P" @WIRE(mode="straight") {%bundle_1:10 %p32};
// %wire_32 @TEXT("<*8>PHI2P", size=1, halign="middle", valign="baseline") => @PLACE(186, 19);
// %p33 = (264, 20);
// %wire_33 = &"PHI2N" @WIRE(mode="straight") {%bundle_0:9 %p33};
// %wire_33 @TEXT("<*7>PHI2N", size=1, halign="middle", valign="baseline") => @PLACE(264, 16);
// %p34 = (188, 23);
// %wire_34 = &"PHI2N" @WIRE(mode="straight") {%bundle_1:9 %p34};
// %wire_34 @TEXT("<*8>PHI2N", size=1, halign="middle", valign="baseline") => @PLACE(188, 19);
// %p35 = (324, 58);
// %wire_35 = &"PHI1EP_B" @WIRE(mode="straight") {#"XCLK_B":4 %p35};
// %wire_35 @TEXT("PHI1EP\_B", size=1, halign="middle", valign="baseline") => @PLACE(320, 58);
// %p36 = (256, 20);
// %wire_36 = &"PHI1EP_B" @WIRE(mode="straight") {%bundle_0:7 %p36};
// %wire_36 @TEXT("<*7>PHI1EP\_B", size=1, halign="middle", valign="baseline") => @PLACE(256, 16);
// %p37 = (222, 57);
// %wire_37 = &"PHI1EP_A" @WIRE(mode="straight") {#"XCLK_A":4 %p37};
// %wire_37 @TEXT("PHI1EP\_A", size=1, halign="middle", valign="baseline") => @PLACE(218, 57);
// %p38 = (180, 23);
// %wire_38 = &"PHI1EP_A" @WIRE(mode="straight") {%bundle_1:7 %p38};
// %wire_38 @TEXT("<*8>PHI1EP\_A", size=1, halign="middle", valign="baseline") => @PLACE(180, 19);
// %p39 = (324, 56);
// %wire_39 = &"PHI1EPBST_B" @WIRE(mode="straight") {#"XCLK_B":3 %p39};
// %wire_39 @TEXT("PHI1EPBST\_B", size=1, halign="middle", valign="baseline") => @PLACE(320, 56);
// %p40 = (258, 20);
// %wire_40 = &"PHI1EPBST_B" @WIRE(mode="straight") {%bundle_0:8 %p40};
// %wire_40 @TEXT("<*7>PHI1EPBST\_B", size=1, halign="middle", valign="baseline") => @PLACE(258, 16);
// %p41 = (222, 55);
// %wire_41 = &"PHI1EPBST_A" @WIRE(mode="straight") {#"XCLK_A":3 %p41};
// %wire_41 @TEXT("PHI1EPBST\_A", size=1, halign="middle", valign="baseline") => @PLACE(218, 55);
// %p42 = (182, 23);
// %wire_42 = &"PHI1EPBST_A" @WIRE(mode="straight") {%bundle_1:8 %p42};
// %wire_42 @TEXT("<*8>PHI1EPBST\_A", size=1, halign="middle", valign="baseline") => @PLACE(182, 19);
// %p43 = (324, 54);
// %wire_43 = &"PHI1EN_B" @WIRE(mode="straight") {#"XCLK_B":2 %p43};
// %wire_43 @TEXT("PHI1EN\_B", size=1, halign="middle", valign="baseline") => @PLACE(320, 54);
// %p44 = (260, 20);
// %wire_44 = &"PHI1EN_B" @WIRE(mode="straight") {%bundle_0:6 %p44};
// %wire_44 @TEXT("<*7>PHI1EN\_B", size=1, halign="middle", valign="baseline") => @PLACE(260, 16);
// %p45 = (222, 53);
// %wire_45 = &"PHI1EN_A" @WIRE(mode="straight") {#"XCLK_A":2 %p45};
// %wire_45 @TEXT("PHI1EN\_A", size=1, halign="middle", valign="baseline") => @PLACE(218, 53);
// %p46 = (184, 23);
// %wire_46 = &"PHI1EN_A" @WIRE(mode="straight") {%bundle_1:6 %p46};
// %wire_46 @TEXT("<*8>PHI1EN\_A", size=1, halign="middle", valign="baseline") => @PLACE(184, 19);
// %p47 = (276, 56);
// %wire_47 = &"PHI1BSTP_B" @WIRE(mode="straight") {#"XBOOT_B":3 %p47};
// %wire_47 @TEXT("PHI1BSTP\_B", size=1, halign="middle", valign="baseline") => @PLACE(272, 56);
// %p48 = (252, 20);
// %wire_48 = &"PHI1BSTP_B" @WIRE(mode="straight") {%bundle_0:5 %p48};
// %wire_48 @TEXT("<*7>PHI1BSTP\_B", size=1, halign="middle", valign="baseline") => @PLACE(252, 16);
// %p49 = (175, 55);
// %wire_49 = &"PHI1BSTP_A" @WIRE(mode="straight") {#"XBOOT_A":3 %p49};
// %wire_49 @TEXT("PHI1BSTP\_A", size=1, halign="middle", valign="baseline") => @PLACE(171, 55);
// %p50 = (176, 23);
// %wire_50 = &"PHI1BSTP_A" @WIRE(mode="straight") {%bundle_1:5 %p50};
// %wire_50 @TEXT("<*8>PHI1BSTP\_A", size=1, halign="middle", valign="baseline") => @PLACE(176, 19);
// %p51 = (276, 54);
// %wire_51 = &"PHI1BSTN_B" @WIRE(mode="straight") {#"XBOOT_B":2 %p51};
// %wire_51 @TEXT("PHI1BSTN\_B", size=1, halign="middle", valign="baseline") => @PLACE(272, 54);
// %p52 = (254, 20);
// %wire_52 = &"PHI1BSTN_B" @WIRE(mode="straight") {%bundle_0:4 %p52};
// %wire_52 @TEXT("<*7>PHI1BSTN\_B", size=1, halign="middle", valign="baseline") => @PLACE(254, 16);
// %p53 = (175, 53);
// %wire_53 = &"PHI1BSTN_A" @WIRE(mode="straight") {#"XBOOT_A":2 %p53};
// %wire_53 @TEXT("PHI1BSTN\_A", size=1, halign="middle", valign="baseline") => @PLACE(171, 53);
// %p54 = (178, 23);
// %wire_54 = &"PHI1BSTN_A" @WIRE(mode="straight") {%bundle_1:4 %p54};
// %wire_54 @TEXT("<*8>PHI1BSTN\_A", size=1, halign="middle", valign="baseline") => @PLACE(178, 19);
// %p55 = (232, -4);
// %wire_55 = &"IB_B" @WIRE(mode="straight") {%p55 %bundle_0:11};
// %wire_55 @TEXT("<*7>IB\_B", size=1, halign="middle", valign="baseline") => @PLACE(236, -4);
// %p56 = (156, -1);
// %wire_56 = &"IB_A" @WIRE(mode="straight") {%p56 %bundle_1:11};
// %wire_56 @TEXT("<*8>IB\_A", size=1, halign="middle", valign="baseline") => @PLACE(160, -1);
// %p57 = (85.4, -53);
// %wire_57 = {&"DN_14" &"DN_13" &"DN_12" &"DN_11" &"DN_10" &"DN_9" &"DN_8" &"DN_7" &"DN_6" &"DN_5" &"DN_4" &"DN_3" &"DN_2" &"DN_1" &"DN_0"} @WIRE(mode="straight") {%port_17:1 %p57};
// %wire_57 @TEXT("DN<14:0>", size=1, halign="middle", valign="middle") => @PLACE(82.2, -53);
// %p58 = (85.4, -45);
// %wire_58 = {&"DP_14" &"DP_13" &"DP_12" &"DP_11" &"DP_10" &"DP_9" &"DP_8" &"DP_7" &"DP_6" &"DP_5" &"DP_4" &"DP_3" &"DP_2" &"DP_1" &"DP_0"} @WIRE(mode="straight") {%port_16:1 %p58};
// %wire_58 @TEXT("DP<14:0>", size=1, halign="middle", valign="middle") => @PLACE(82.2, -45);
// %p59 = (297, 0);
// %wire_59 = {&"D_14" &"D_13" &"D_12" &"D_11" &"D_10" &"D_9" &"D_8" &"D_7" &"D_6" &"D_5" &"D_4" &"D_3" &"D_2" &"D_1" &"D_0"} @WIRE(mode="straight") {%p59 #"XENC":5};
// %p60 = (85.4, -37);
// %wire_60 = {&"D_14" &"D_13" &"D_12" &"D_11" &"D_10" &"D_9" &"D_8" &"D_7" &"D_6" &"D_5" &"D_4" &"D_3" &"D_2" &"D_1" &"D_0"} @WIRE(mode="straight") {%port_15:1 %p60};
// %wire_60 @TEXT("D<14:0>", size=1, halign="middle", valign="middle") => @PLACE(82.2, -37);
// %wire_59 @TEXT("D<14:0>", size=1, halign="middle", valign="baseline") => @PLACE(301, 0);
// %p61 = (85.4, -29);
// %wire_61 = &"IB_B" @WIRE(mode="straight") {%port_14:p %p61};
// %p62 = (317, -30);
// %wire_62 = &"IB_B" @WIRE(mode="straight") {#"C0_B":1 %p62};
// %p63 = (298, -31);
// %wire_63 = &"IB_B" @WIRE(mode="straight") {#"M1_B":2 %p63};
// %p64 = (285, -39);
// %wire_64 = &"IB_B" @WIRE(mode="straight") {#"M24_B":2 %p64};
// %p65 = (254, -28);
// %wire_65 = &"IB_B" @WIRE(mode="straight") {#"M0_B":1 %p65};
// %wire_65 @TEXT("IB\_B", size=1, halign="middle", valign="baseline") => @PLACE(254, -32);
// %wire_64 @TEXT("IB\_B", size=1, halign="middle", valign="baseline") => @PLACE(281, -39);
// %wire_63 @TEXT("IB\_B", size=1, halign="middle", valign="baseline") => @PLACE(298, -35);
// %wire_62 @TEXT("IB\_B", size=1, halign="middle", valign="baseline") => @PLACE(317, -34);
// %wire_61 @TEXT("IB\_B", size=1, halign="middle", valign="middle") => @PLACE(82.2, -29);
// %p66 = (85.4, -21);
// %wire_66 = &"IB_A" @WIRE(mode="straight") {%port_13:p %p66};
// %p67 = (231, -29);
// %wire_67 = &"IB_A" @WIRE(mode="straight") {#"C0_A":1 %p67};
// %p68 = (212, -29);
// %wire_68 = &"IB_A" @WIRE(mode="straight") {#"M1_A":2 %p68};
// %p69 = (200, -38);
// %wire_69 = &"IB_A" @WIRE(mode="straight") {#"M24_A":2 %p69};
// %p70 = (167, -27);
// %wire_70 = &"IB_A" @WIRE(mode="straight") {#"M0_A":1 %p70};
// %wire_70 @TEXT("IB\_A", size=1, halign="middle", valign="baseline") => @PLACE(167, -31);
// %wire_69 @TEXT("IB\_A", size=1, halign="middle", valign="baseline") => @PLACE(196, -38);
// %wire_68 @TEXT("IB\_A", size=1, halign="middle", valign="baseline") => @PLACE(212, -33);
// %wire_67 @TEXT("IB\_A", size=1, halign="middle", valign="baseline") => @PLACE(231, -33);
// %wire_66 @TEXT("IB\_A", size=1, halign="middle", valign="middle") => @PLACE(82.2, -21);
// %p71 = (85.4, -13);
// %wire_71 = &"VREFN" @WIRE(mode="straight") {%port_12:p %p71};
// %p72 = (121, -23);
// %wire_72 = &"VREFN" @WIRE(mode="straight") {#"XRDAC":16 %p72};
// %wire_72 @TEXT("VREFN", size=1, halign="middle", valign="baseline") => @PLACE(121, -27);
// %wire_71 @TEXT("VREFN", size=1, halign="middle", valign="middle") => @PLACE(82.2, -13);
// %p73 = (85.4, -5);
// %wire_73 = &"VREFP" @WIRE(mode="straight") {%port_11:p %p73};
// %p74 = (111, -31);
// %wire_74 = &"VREFP" @WIRE(mode="straight") {%p74 #"XRDAC":17};
// %wire_74 @TEXT("VREFP", size=1, halign="middle", valign="baseline") => @PLACE(115, -31);
// %wire_73 @TEXT("VREFP", size=1, halign="middle", valign="middle") => @PLACE(82.2, -5);
// %p75 = (85.4, 3);
// %wire_75 = &"VCM" @WIRE(mode="straight") {%port_10:p %p75};
// %p76 = (242, -39);
// %wire_76 = &"VCM" @WIRE(mode="straight") {%p76 #"M0_B":2};
// %p77 = (155, -38);
// %wire_77 = &"VCM" @WIRE(mode="straight") {%p77 #"M0_A":2};
// %wire_77 @TEXT("VCM", size=1, halign="middle", valign="baseline") => @PLACE(159, -38);
// %wire_76 @TEXT("VCM", size=1, halign="middle", valign="baseline") => @PLACE(246, -39);
// %wire_75 @TEXT("VCM", size=1, halign="middle", valign="middle") => @PLACE(82.2, 3);
// %p78 = (322, 16);
// %wire_78 = &"VSS" @WIRE(mode="straight") {#"XENC":21 %p78};
// %p79 = (85.4, 11);
// %wire_79 = &"VSS" @WIRE(mode="straight") {%port_9:p %p79};
// %p80 = (317, -52);
// %wire_80 = &"VSS" @WIRE(mode="straight") {%p80 #"C0_B":2};
// %p81 = (299, -51);
// %wire_81 = &"VSS" @WIRE(mode="straight") {%p81 #"M1_B":4};
// %p82 = (309, -43);
// %wire_82 = &"VSS" @WIRE(mode="straight") {#"M1_B":3 %p82};
// %p83 = (287, -43);
// %wire_83 = &"VSS" @WIRE(mode="straight") {%p83 #"M1_B":1};
// %p84 = (265, -40);
// %wire_84 = &"VSS" @WIRE(mode="straight") {%p84 #"M24_B":4};
// %p85 = (273, -50);
// %wire_85 = &"VSS" @WIRE(mode="straight") {%p85 #"M24_B":3};
// %p86 = (262, -40);
// %wire_86 = &"VSS" @WIRE(mode="straight") {#"M0_B":4 %p86};
// %p87 = (305, 38);
// %wire_87 = &"VSS" @WIRE(mode="straight") {%p87 #"XCLK_B":6};
// %p88 = (257, 37);
// %wire_88 = &"VSS" @WIRE(mode="straight") {%p88 #"XBOOT_B":7};
// %p89 = (231, -51);
// %wire_89 = &"VSS" @WIRE(mode="straight") {%p89 #"C0_A":2};
// %p90 = (213, -49);
// %wire_90 = &"VSS" @WIRE(mode="straight") {%p90 #"M1_A":4};
// %p91 = (223, -41);
// %wire_91 = &"VSS" @WIRE(mode="straight") {#"M1_A":3 %p91};
// %p92 = (201, -41);
// %wire_92 = &"VSS" @WIRE(mode="straight") {%p92 #"M1_A":1};
// %p93 = (180, -39);
// %wire_93 = &"VSS" @WIRE(mode="straight") {%p93 #"M24_A":4};
// %p94 = (188, -49);
// %wire_94 = &"VSS" @WIRE(mode="straight") {%p94 #"M24_A":3};
// %p95 = (175, -39);
// %wire_95 = &"VSS" @WIRE(mode="straight") {#"M0_A":4 %p95};
// %p96 = (203, 37);
// %wire_96 = &"VSS" @WIRE(mode="straight") {%p96 #"XCLK_A":6};
// %p97 = (156, 36);
// %wire_97 = &"VSS" @WIRE(mode="straight") {%p97 #"XBOOT_A":7};
// %wire_97 @TEXT("VSS", size=1, halign="middle", valign="baseline") => @PLACE(156, 40);
// %wire_96 @TEXT("VSS", size=1, halign="middle", valign="baseline") => @PLACE(203, 41);
// %wire_95 @TEXT("VSS", size=1, halign="middle", valign="baseline") => @PLACE(171, -39);
// %wire_94 @TEXT("VSS", size=1, halign="middle", valign="baseline") => @PLACE(188, -45);
// %wire_93 @TEXT("VSS", size=1, halign="middle", valign="baseline") => @PLACE(184, -39);
// %wire_92 @TEXT("VSS", size=1, halign="middle", valign="baseline") => @PLACE(205, -41);
// %wire_91 @TEXT("VSS", size=1, halign="middle", valign="baseline") => @PLACE(219, -41);
// %wire_90 @TEXT("VSS", size=1, halign="middle", valign="baseline") => @PLACE(213, -45);
// %wire_89 @TEXT("VSS", size=1, halign="middle", valign="baseline") => @PLACE(231, -47);
// %wire_88 @TEXT("VSS", size=1, halign="middle", valign="baseline") => @PLACE(257, 41);
// %wire_87 @TEXT("VSS", size=1, halign="middle", valign="baseline") => @PLACE(305, 42);
// %wire_86 @TEXT("VSS", size=1, halign="middle", valign="baseline") => @PLACE(258, -40);
// %wire_85 @TEXT("VSS", size=1, halign="middle", valign="baseline") => @PLACE(273, -46);
// %wire_84 @TEXT("VSS", size=1, halign="middle", valign="baseline") => @PLACE(269, -40);
// %wire_83 @TEXT("VSS", size=1, halign="middle", valign="baseline") => @PLACE(291, -43);
// %wire_82 @TEXT("VSS", size=1, halign="middle", valign="baseline") => @PLACE(305, -43);
// %wire_81 @TEXT("VSS", size=1, halign="middle", valign="baseline") => @PLACE(299, -47);
// %wire_80 @TEXT("VSS", size=1, halign="middle", valign="baseline") => @PLACE(317, -48);
// %wire_79 @TEXT("VSS", size=1, halign="middle", valign="middle") => @PLACE(82.2, 11);
// %wire_78 @TEXT("VSS", size=1, halign="middle", valign="baseline") => @PLACE(322, 12);
// %p98 = (324, 16);
// %wire_98 = &"VDD" @WIRE(mode="straight") {#"XENC":20 %p98};
// %p99 = (85.4, 19);
// %wire_99 = &"VDD" @WIRE(mode="straight") {%port_8:p %p99};
// %p100 = (303, 38);
// %wire_100 = &"VDD" @WIRE(mode="straight") {%p100 #"XCLK_B":5};
// %p101 = (255, 37);
// %wire_101 = &"VDD" @WIRE(mode="straight") {%p101 #"XBOOT_B":4};
// %p102 = (201, 37);
// %wire_102 = &"VDD" @WIRE(mode="straight") {%p102 #"XCLK_A":5};
// %p103 = (154, 36);
// %wire_103 = &"VDD" @WIRE(mode="straight") {%p103 #"XBOOT_A":4};
// %wire_103 @TEXT("VDD", size=1, halign="middle", valign="baseline") => @PLACE(154, 40);
// %wire_102 @TEXT("VDD", size=1, halign="middle", valign="baseline") => @PLACE(201, 41);
// %wire_101 @TEXT("VDD", size=1, halign="middle", valign="baseline") => @PLACE(255, 41);
// %wire_100 @TEXT("VDD", size=1, halign="middle", valign="baseline") => @PLACE(303, 42);
// %wire_99 @TEXT("VDD", size=1, halign="middle", valign="middle") => @PLACE(82.2, 19);
// %wire_98 @TEXT("VDD", size=1, halign="middle", valign="baseline") => @PLACE(324, 12);
// %p104 = (85.4, 27);
// %wire_104 = {&"VOSN_14" &"VOSN_13" &"VOSN_12" &"VOSN_11" &"VOSN_10" &"VOSN_9" &"VOSN_8" &"VOSN_7" &"VOSN_6" &"VOSN_5" &"VOSN_4" &"VOSN_3" &"VOSN_2" &"VOSN_1" &"VOSN_0"} @WIRE(mode="straight") {%port_7:1 %p104};
// %wire_104 @TEXT("VOSN<14:0>", size=1, halign="middle", valign="middle") => @PLACE(82.2, 27);
// %p105 = (85.4, 35);
// %wire_105 = {&"VOSP_14" &"VOSP_13" &"VOSP_12" &"VOSP_11" &"VOSP_10" &"VOSP_9" &"VOSP_8" &"VOSP_7" &"VOSP_6" &"VOSP_5" &"VOSP_4" &"VOSP_3" &"VOSP_2" &"VOSP_1" &"VOSP_0"} @WIRE(mode="straight") {%port_6:1 %p105};
// %wire_105 @TEXT("VOSP<14:0>", size=1, halign="middle", valign="middle") => @PLACE(82.2, 35);
// %p106 = (85.4, 43);
// %wire_106 = &"PHI2N" @WIRE(mode="straight") {%port_5:p %p106};
// %wire_106 @TEXT("PHI2N", size=1, halign="middle", valign="middle") => @PLACE(82.2, 43);
// %p107 = (85.4, 51);
// %wire_107 = &"PHI2P" @WIRE(mode="straight") {%port_4:p %p107};
// %wire_107 @TEXT("PHI2P", size=1, halign="middle", valign="middle") => @PLACE(82.2, 51);
// %p108 = (85.4, 59);
// %wire_108 = &"PHI1N" @WIRE(mode="straight") {%port_3:p %p108};
// %p109 = (256, 73);
// %wire_109 = &"PHI1N" @WIRE(mode="straight") {#"XBOOT_B":1 %p109};
// %p110 = (155, 72);
// %wire_110 = &"PHI1N" @WIRE(mode="straight") {#"XBOOT_A":1 %p110};
// %wire_110 @TEXT("PHI1N", size=1, halign="middle", valign="baseline") => @PLACE(155, 68);
// %wire_109 @TEXT("PHI1N", size=1, halign="middle", valign="baseline") => @PLACE(256, 69);
// %wire_108 @TEXT("PHI1N", size=1, halign="middle", valign="middle") => @PLACE(82.2, 59);
// %p111 = (85.4, 67);
// %wire_111 = &"PHI1EN" @WIRE(mode="straight") {%port_2:p %p111};
// %p112 = (284, 56);
// %wire_112 = &"PHI1EN" @WIRE(mode="straight") {%p112 #"XCLK_B":1};
// %p113 = (182, 55);
// %wire_113 = &"PHI1EN" @WIRE(mode="straight") {%p113 #"XCLK_A":1};
// %wire_113 @TEXT("PHI1EN", size=1, halign="middle", valign="baseline") => @PLACE(186, 55);
// %wire_112 @TEXT("PHI1EN", size=1, halign="middle", valign="baseline") => @PLACE(288, 56);
// %wire_111 @TEXT("PHI1EN", size=1, halign="middle", valign="middle") => @PLACE(82.2, 67);
// %p114 = (85.4, 75);
// %wire_114 = &"VINN" @WIRE(mode="straight") {%port_1:p %p114};
// %p115 = (236, 54);
// %wire_115 = &"VINN" @WIRE(mode="straight") {%p115 #"XBOOT_B":5};
// %p116 = (135, 53);
// %wire_116 = &"VINN" @WIRE(mode="straight") {%p116 #"XBOOT_A":5};
// %wire_116 @TEXT("VINN", size=1, halign="middle", valign="baseline") => @PLACE(139, 53);
// %wire_115 @TEXT("VINN", size=1, halign="middle", valign="baseline") => @PLACE(240, 54);
// %wire_114 @TEXT("VINN", size=1, halign="middle", valign="middle") => @PLACE(82.2, 75);
// %p117 = (85.4, 83);
// %wire_117 = &"VINP" @WIRE(mode="straight") {%port_0:p %p117};
// %p118 = (236, 56);
// %wire_118 = &"VINP" @WIRE(mode="straight") {%p118 #"XBOOT_B":6};
// %p119 = (135, 55);
// %wire_119 = &"VINP" @WIRE(mode="straight") {%p119 #"XBOOT_A":6};
// %wire_119 @TEXT("VINP", size=1, halign="middle", valign="baseline") => @PLACE(139, 55);
// %wire_118 @TEXT("VINP", size=1, halign="middle", valign="baseline") => @PLACE(240, 56);
// %wire_117 @TEXT("VINP", size=1, halign="middle", valign="middle") => @PLACE(82.2, 83)
// }
ends L3_stage1_flash4_FS2
