// Explicit saved-library assembly.
simulator lang=spectre
include "Buffer_Main.scs"
include "tb_Pipeline_Ideal_Model_DiffSamp.scs"
