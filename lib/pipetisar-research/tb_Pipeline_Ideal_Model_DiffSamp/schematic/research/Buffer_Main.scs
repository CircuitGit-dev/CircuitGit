// Generated for: spectre
// @RNL(type="header") {
//   @VERSION("0.3");
//   @USE-PACKAGE(name="rnl-std-spectre", version="0.3", path="rnl-std-spectre.rnl");
//   @USE-PACKAGE(name="eda-symbol", version="0.1", path="eda-symbol.rnl");
//   @USE-PACKAGE(name="eda-style", version="0.1", path="eda-style.rnl")
// }
// Generated on: Nov  9 19:36:53 2026
// Design library name: 2026_PIPETISAR_RESEARCH
// Design cell name: Buffer_Main
// Design view name: schematic
simulator lang=spectre
global 0

// Library name: 2026_PIPETISAR_RESEARCH
// Cell name: Buffer_Main
// View name: schematic
subckt Buffer_Main VDD VINN VINP VOUTN VOUTP VSS VCM
    E1 (VOUTN VCM VINN VCM) vcvs gain=0.9 min=-0.5 max=0.5
    E0 (VOUTP VCM VINP VCM) vcvs gain=0.9 min=-0.5 max=0.5
// @RNL(author="rnl-virtuoso") {
//   %block_symbol = @DEFINE-SYMBOL(box=[4, -8, 16, 5]) {
//     @LINE {(0, 1) (4, 1)};
//     @LINE {(0, -3) (4, -3)};
//     @LINE {(17, -3) (13, -3)};
//     @LINE {(17, 1) (13, 1)};
//     @LINE {(10, 6) (10, 2)};
//     @LINE {(10, -9) (10, -5)};
//     @LINE {(4, 5) (4, -8) (16, -1) (4, 5)};
//     @LINE {(8, 7) (8, 3)};
//     ? @TEXT("${name}", size=1, halign="start", valign="middle", key="name") => @PLACE(11, 3);
//     ? @TEXT("${model}", size=1, halign="middle", valign="middle", key="model") => @PLACE(10, -0.5);
//     (0, 1) @PIN(terminal="VINP");
//     (0.6, 2) @TEXT("VINP", size=1, halign="start", valign="middle");
//     (0, -3) @PIN(terminal="VINN");
//     (0.6, -4) @TEXT("VINN", size=1, halign="start", valign="middle");
//     (17, -3) @PIN(terminal="VOUTP");
//     (17.4, -4) @TEXT("VOUTP", size=1, halign="end", valign="middle");
//     (17, 1) @PIN(terminal="VOUTN");
//     (17.4, 2) @TEXT("VOUTN", size=1, halign="end", valign="middle");
//     (10, 6) @PIN(terminal="VDD");
//     (9, 5.4) @TEXT("VDD", size=1, halign="end", valign="middle", rotate=90);
//     (10, -9) @PIN(terminal="VSS");
//     (9, -8.4) @TEXT("VSS", size=1, halign="start", valign="middle", rotate=90);
//     (8, 7) @PIN(terminal="VCM");
//     (7, 6.4) @TEXT("VCM", size=1, halign="end", valign="middle", rotate=90)
//   };
//   # @SET-SYMBOL %block_symbol;
//   #"E1" @SET-SYMBOL $VCVS_4TERM;
//   #"E1" @PLACE(-10, -4) => @ORIENT("MX");
//   #"E0" @SET-SYMBOL $VCVS_4TERM;
//   #"E0" @PLACE(-10, 6) => @ORIENT("R0");
//   %marker_1 = (-25, -7);
//   $FIGURE @ATTACH %marker_1 => @SET-SYMBOL $NO_CONNECT_SYMBOL => @ORIENT("R90");
//   %marker_2 = (-25, -4);
//   $FIGURE @ATTACH %marker_2 => @SET-SYMBOL $NO_CONNECT_SYMBOL => @ORIENT("R90");
//   %input_port_symbol = @DEFINE-SYMBOL(box=[-2, -1, 0, 1]) {
//       @LINE(fill="linecolor", linestyle="none") {(-2, -0.9) (-2, 0.9) (-0.9, 0.9) (0, 0) (-0.9, -0.9) (-2, -0.9)};
//       (0, 0) @PIN(terminal=1, direction="right");
//       ? @TEXT("${name}", key="name", halign="middle") => @PLACE(-1, 1.6)
//     };
//   %port_0 = $IO_PORT @ATTACH &"VINP" => @PLACE(-24, 8) => @ORIENT("R0");
//   %port_0 @SET-SYMBOL %input_port_symbol;
//   %port_0 @TEXT("VINP", key="name");
//   %port_1 = $IO_PORT @ATTACH &"VINN" => @PLACE(-24, 5) => @ORIENT("R0");
//   %port_1 @SET-SYMBOL %input_port_symbol;
//   %port_1 @TEXT("VINN", key="name");
//   %output_port_symbol = @DEFINE-SYMBOL(box=[0, -1, 2, 1]) {
//       @LINE(fill="linecolor", linestyle="none") {(0, -0.9) (0, 0.9) (1.1, 0.9) (2, 0) (1.1, -0.9) (0, -0.9)};
//       (0, 0) @PIN(terminal=1, direction="left");
//       ? @TEXT("${name}", key="name", halign="middle") => @PLACE(1, 1.6)
//     };
//   %port_2 = $IO_PORT @ATTACH &"VOUTN" => @PLACE(-26, 2) => @ORIENT("R0");
//   %port_2 @SET-SYMBOL %output_port_symbol;
//   %port_2 @TEXT("VOUTN", key="name");
//   %port_3 = $IO_PORT @ATTACH &"VOUTP" => @PLACE(-26, -1) => @ORIENT("R0");
//   %port_3 @SET-SYMBOL %output_port_symbol;
//   %port_3 @TEXT("VOUTP", key="name");
//   %port_4 = $IO_PORT @ATTACH &"VDD" => @PLACE(-25, -4) => @ORIENT("R0");
//   %port_5 = $IO_PORT @ATTACH &"VSS" => @PLACE(-25, -7) => @ORIENT("R0");
//   %port_6 = $IO_PORT @ATTACH &"VCM" => @PLACE(-25, -10) => @ORIENT("R0");
//   %wire_0 = &"VSS" @WIRE(mode="straight") {%port_5:p %marker_1};
//   %wire_1 = &"VDD" @WIRE(mode="straight") {%port_4:p %marker_2};
//   %p0 = (-13, 1);
//   %p1 = (-9, 1);
//   %wire_2 = &"VCM" @WIRE(mode="straight") {%p0 %p1};
//   %wire_3 = &"VCM" @WIRE(mode="straight") {#"E1":2 %p1};
//   %wire_4 = &"VCM" @WIRE(mode="straight") {%p1 #"E0":2};
//   %p2 = (-13, 5);
//   %wire_5 = &"VCM" @WIRE(mode="straight") {%p0 %p2};
//   %wire_6 = &"VCM" @WIRE(mode="straight") {%p2 #"E0":4};
//   %p3 = (-13, -3);
//   %wire_7 = &"VCM" @WIRE(mode="straight") {%p3 #"E1":4};
//   %wire_8 = &"VCM" @WIRE(mode="straight") {%p3 %p0};
//   %wire_2 @TEXT("VCM", size=1, halign="middle", valign="baseline") => @PLACE(-11, 1.7);
//   %p4 = (-9, 13);
//   %wire_9 = &"VOUTP" @WIRE(mode="straight") {#"E0":1 %p4};
//   %wire_9 @TEXT("VOUTP", size=1, halign="start", valign="baseline", rotate=90) => @PLACE(-9.7, 9.4);
//   %p5 = (-9, -11);
//   %wire_10 = &"VOUTN" @WIRE(mode="straight") {%p5 #"E1":1};
//   %wire_10 @TEXT("VOUTN", size=1, halign="end", valign="baseline", rotate=90) => @PLACE(-9.7, -7.4);
//   %p6 = (-15, 7);
//   %wire_11 = &"VINP" @WIRE(mode="straight") {%p6 #"E0":3};
//   %wire_11 @TEXT("VINP", size=1, halign="end", valign="baseline") => @PLACE(-11.4, 7.7);
//   %p7 = (-15, -5);
//   %wire_12 = &"VINN" @WIRE(mode="straight") {%p7 #"E1":3};
//   %wire_12 @TEXT("VINN", size=1, halign="end", valign="baseline") => @PLACE(-11.4, -4.3);
//   $JUNCTION @ATTACH %p0;
//   $JUNCTION @ATTACH %p1
// }
ends Buffer_Main
