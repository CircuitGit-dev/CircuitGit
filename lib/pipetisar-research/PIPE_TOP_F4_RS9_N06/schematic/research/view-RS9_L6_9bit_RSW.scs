// Explicit saved-library assembly.
simulator lang=spectre
include "RS9_L6_9bit_RSW.scs"
