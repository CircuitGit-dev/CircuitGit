// Explicit saved-library assembly.
simulator lang=spectre
include "RS9_L6_SR_latch_1.scs"
