// Generated for: spectre
// @RNL(type="header") {
//   @VERSION("0.3");
//   @USE-PACKAGE(name="rnl-std-spectre", version="0.3", path="rnl-std-spectre.rnl");
//   @USE-PACKAGE(name="eda-symbol", version="0.1", path="eda-symbol.rnl");
//   @USE-PACKAGE(name="eda-style", version="0.1", path="eda-style.rnl")
// }
// Generated on: Nov  9 19:40:55 2026
// Design library name: 2026_PIPETISAR_RESEARCH
// Design cell name: PIPE_TOP_F4_RS9_N06
// Design view name: schematic
simulator lang=spectre
global 0

// Library name: 2026_PIPETISAR_RESEARCH
// Cell name: PIPE_OTA_Diff_Ideal
// View name: schematic
// End of subcircuit definition.

// Library name: 2026_PIPETISAR_RESEARCH
// Cell name: Switch
// View name: schematic
// End of subcircuit definition.

// Library name: 2026_PIPETISAR_RESEARCH
// Cell name: PIPE_MDAC4_G8_SC
// View name: schematic
// End of subcircuit definition.

// Library name: 2026_PIPETISAR_RESEARCH
// Cell name: RS9_L5_9bit_Bootstrap
// View name: schematic
// End of subcircuit definition.

// Library name: 2026_PIPETISAR_RESEARCH
// Cell name: RS9_L5_9bit_Comparator_LN
// View name: schematic
// End of subcircuit definition.

// Library name: 2026_PIPETISAR_RESEARCH
// Cell name: RS9_L6_SR_latch_1
// View name: schematic
// End of subcircuit definition.

// Library name: 2026_PIPETISAR_RESEARCH
// Cell name: RS9_L6_9bit_REF_Logic
// View name: schematic
// End of subcircuit definition.

// Library name: 2026_PIPETISAR_RESEARCH
// Cell name: RS9_L5_9bit_SAR_Logic_1
// View name: schematic
// End of subcircuit definition.

// Library name: 2026_PIPETISAR_RESEARCH
// Cell name: RS9_L8_9bit_CDAC_UNIT
// View name: schematic
// End of subcircuit definition.

// Library name: 2026_PIPETISAR_RESEARCH
// Cell name: RS9_L7_9bit_CDAC
// View name: schematic
// End of subcircuit definition.

// Library name: 2026_PIPETISAR_RESEARCH
// Cell name: RS9_L6_9bit_RSW
// View name: schematic
// End of subcircuit definition.

// Library name: 2026_PIPETISAR_RESEARCH
// Cell name: RS9_L5_9bit_RSW_CDAC
// View name: schematic
// End of subcircuit definition.

// Library name: 2026_PIPETISAR_RESEARCH
// Cell name: RS9_L3_9bit_SAR_2
// View name: schematic
// End of subcircuit definition.

// Library name: 2026_PIPETISAR_RESEARCH
// Cell name: PIPE_SAR9_Real_N06
// View name: schematic
// End of subcircuit definition.

// Library name: tcbn28hpcplusbwp12t30p140ulvt
// Cell name: ND2D0BWP12T30P140ULVT
// View name: schematic
// End of subcircuit definition.

// Library name: tsmcN28
// Cell name: trans_ulvt_mac
// View name: schematic
// End of subcircuit definition.

// Library name: 2026_PIPETISAR_RESEARCH
// Cell name: L4_stage1_flash_comparator
// View name: schematic
// End of subcircuit definition.

// Library name: 2026_PIPETISAR_RESEARCH
// Cell name: L4_stage1_flash_bootstrapper
// View name: schematic
// End of subcircuit definition.

// Library name: 2026_PIPETISAR_RESEARCH
// Cell name: L4_stage1_flash_clkbooster
// View name: schematic
// End of subcircuit definition.

// Library name: 2026_PIPETISAR_RESEARCH
// Cell name: L4_stage1_flash4_encoder
// View name: schematic
// End of subcircuit definition.

// Library name: 2026_PIPETISAR_RESEARCH
// Cell name: L4_stage1_flash4_rdac_FS2
// View name: schematic
// End of subcircuit definition.

// Library name: 2026_PIPETISAR_RESEARCH
// Cell name: L3_stage1_flash4_FS2
// View name: schematic
// End of subcircuit definition.

// Library name: 2026_PIPETISAR_RESEARCH
// Cell name: PIPE_TOP_F4_RS9_N06
// View name: schematic
subckt PIPE_TOP_F4_RS9_N06 AMP BIN_3 BIN_2 BIN_1 BIN_0 CHANNEL CODE_11 \
        CODE_10 CODE_9 CODE_8 CODE_7 CODE_6 CODE_5 CODE_4 CODE_3 CODE_2 \
        CODE_1 CODE_0 D_14 D_13 D_12 D_11 D_10 D_9 D_8 D_7 D_6 D_5 D_4 D_3 \
        D_2 D_1 D_0 DA DB IB_A IB_B OVERFLOW RECON RON ROP TA TB TRACK \
        VALID VCM VDD VINN VINP VREFN VREFP VSS
    XRA (AMP DACN DACP RESET RON ROP TRACK VCM VDD VINN VINP VSS) \
        PIPE_MDAC4_G8_SC
    S_BN (RON HBN TB) Switch Rseries=50
    S_BP (ROP HBP TB) Switch Rseries=50
    S_AN (RON HAN TA) Switch Rseries=50
    S_AP (ROP HAP TA) Switch Rseries=50
    XCLK (TRACK AMP RESET TA TB PHI1EN PHI1N PHI2P PHI2N VDD VSS) \
        PIPE_Clock250_250_500 tper=Tper ttrack=Ttrack tamp=Tamp \
        guard=Tguard tr=TrModel
    XSARB (BUSYB DB K_3 K_2 K_1 K_0 KB_3 KB_2 KB_1 KB_0 OFB QB_8 QB_7 QB_6 \
        QB_5 QB_4 QB_3 QB_2 QB_1 QB_0 STEPB TB VCM VDACB VDD VHB HBN HBP \
        VREFN VREFP VSS) PIPE_SAR9_Real_N06
    XSARA (BUSYA DA K_3 K_2 K_1 K_0 KA_3 KA_2 KA_1 KA_0 OFA QA_8 QA_7 QA_6 \
        QA_5 QA_4 QA_3 QA_2 QA_1 QA_0 STEPA TA VCM VDACA VDD VHA HAN HAP \
        VREFN VREFP VSS) PIPE_SAR9_Real_N06
    XMERGE (QA_8 QA_7 QA_6 QA_5 QA_4 QA_3 QA_2 QA_1 QA_0 QB_8 QB_7 QB_6 \
        QB_5 QB_4 QB_3 QB_2 QB_1 QB_0 KA_3 KA_2 KA_1 KA_0 KB_3 KB_2 KB_1 \
        KB_0 DA DB OFA OFB CODE_11 CODE_10 CODE_9 CODE_8 CODE_7 CODE_6 \
        CODE_5 CODE_4 CODE_3 CODE_2 CODE_1 CODE_0 VALID CHANNEL OVERFLOW \
        RECON VDD VSS) RS9_Merge_N06 vfs=Vref tr=TrModel
    CPROBE7 (BUSYB VSS) capacitor c=1a
    CPROBE6 (BUSYA VSS) capacitor c=1a
    CPROBE5 (STEPB VSS) capacitor c=1a
    CPROBE4 (STEPA VSS) capacitor c=1a
    CPROBE3 (VHB VSS) capacitor c=1a
    CPROBE2 (VHA VSS) capacitor c=1a
    CPROBE1 (VDACB VSS) capacitor c=1a
    CPROBE0 (VDACA VSS) capacitor c=1a
    C_BIN_3 (BIN_3 VSS) capacitor c=Cflash
    C_BIN_2 (BIN_2 VSS) capacitor c=Cflash
    C_BIN_1 (BIN_1 VSS) capacitor c=Cflash
    C_BIN_0 (BIN_0 VSS) capacitor c=Cflash
    C_DN_14 (DN_14 VSS) capacitor c=Cflash
    C_DN_13 (DN_13 VSS) capacitor c=Cflash
    C_DN_12 (DN_12 VSS) capacitor c=Cflash
    C_DN_11 (DN_11 VSS) capacitor c=Cflash
    C_DN_10 (DN_10 VSS) capacitor c=Cflash
    C_DN_9 (DN_9 VSS) capacitor c=Cflash
    C_DN_8 (DN_8 VSS) capacitor c=Cflash
    C_DN_7 (DN_7 VSS) capacitor c=Cflash
    C_DN_6 (DN_6 VSS) capacitor c=Cflash
    C_DN_5 (DN_5 VSS) capacitor c=Cflash
    C_DN_4 (DN_4 VSS) capacitor c=Cflash
    C_DN_3 (DN_3 VSS) capacitor c=Cflash
    C_DN_2 (DN_2 VSS) capacitor c=Cflash
    C_DN_1 (DN_1 VSS) capacitor c=Cflash
    C_DN_0 (DN_0 VSS) capacitor c=Cflash
    C_DP_14 (DP_14 VSS) capacitor c=Cflash
    C_DP_13 (DP_13 VSS) capacitor c=Cflash
    C_DP_12 (DP_12 VSS) capacitor c=Cflash
    C_DP_11 (DP_11 VSS) capacitor c=Cflash
    C_DP_10 (DP_10 VSS) capacitor c=Cflash
    C_DP_9 (DP_9 VSS) capacitor c=Cflash
    C_DP_8 (DP_8 VSS) capacitor c=Cflash
    C_DP_7 (DP_7 VSS) capacitor c=Cflash
    C_DP_6 (DP_6 VSS) capacitor c=Cflash
    C_DP_5 (DP_5 VSS) capacitor c=Cflash
    C_DP_4 (DP_4 VSS) capacitor c=Cflash
    C_DP_3 (DP_3 VSS) capacitor c=Cflash
    C_DP_2 (DP_2 VSS) capacitor c=Cflash
    C_DP_1 (DP_1 VSS) capacitor c=Cflash
    C_DP_0 (DP_0 VSS) capacitor c=Cflash
    C_D_14 (D_14 VSS) capacitor c=Cflash
    C_D_13 (D_13 VSS) capacitor c=Cflash
    C_D_12 (D_12 VSS) capacitor c=Cflash
    C_D_11 (D_11 VSS) capacitor c=Cflash
    C_D_10 (D_10 VSS) capacitor c=Cflash
    C_D_9 (D_9 VSS) capacitor c=Cflash
    C_D_8 (D_8 VSS) capacitor c=Cflash
    C_D_7 (D_7 VSS) capacitor c=Cflash
    C_D_6 (D_6 VSS) capacitor c=Cflash
    C_D_5 (D_5 VSS) capacitor c=Cflash
    C_D_4 (D_4 VSS) capacitor c=Cflash
    C_D_3 (D_3 VSS) capacitor c=Cflash
    C_D_2 (D_2 VSS) capacitor c=Cflash
    C_D_1 (D_1 VSS) capacitor c=Cflash
    C_D_0 (D_0 VSS) capacitor c=Cflash
    CH_BN (HBN VCM) capacitor c=Cs2
    CH_BP (HBP VCM) capacitor c=Cs2
    CH_AN (HAN VCM) capacitor c=Cs2
    CH_AP (HAP VCM) capacitor c=Cs2
    XFLASH (BIN_3 BIN_2 BIN_1 BIN_0 D_14 D_13 D_12 D_11 D_10 D_9 D_8 D_7 \
        D_6 D_5 D_4 D_3 D_2 D_1 D_0 DN_14 DN_13 DN_12 DN_11 DN_10 DN_9 \
        DN_8 DN_7 DN_6 DN_5 DN_4 DN_3 DN_2 DN_1 DN_0 DP_14 DP_13 DP_12 \
        DP_11 DP_10 DP_9 DP_8 DP_7 DP_6 DP_5 DP_4 DP_3 DP_2 DP_1 DP_0 IB_A \
        IB_B PHI1EN PHI1N PHI2N PHI2P VCM VDD VINN VINP VCM VCM VCM VCM \
        VCM VCM VCM VCM VCM VCM VCM VCM VCM VCM VCM VCM VCM VCM VCM VCM \
        VCM VCM VCM VCM VCM VCM VCM VCM VCM VCM VREFN VREFP VSS) \
        L3_stage1_flash4_FS2
    XDAC (D_14 D_13 D_12 D_11 D_10 D_9 D_8 D_7 D_6 D_5 D_4 D_3 D_2 D_1 D_0 \
        DACP DACN K_3 K_2 K_1 K_0 VCM VREFP VREFN VDD VSS) \
        PIPE_ThermDAC4_FS2
// @RNL(author="rnl-virtuoso") {
//   %block_symbol = @DEFINE-SYMBOL(box=[0, -140.8, 86.4, 4.8]) {
//     @RECTANGLE {(0, -140.8) (86.4, 4.8)};
//     (43.2, 10.4) @TEXT("PIPE-TI-SAR  /  12b", size=4.6, halign="middle", valign="middle");
//     ? @TEXT("${name}", size=3.8, halign="middle", valign="middle", key="name") => @PLACE(43.2, -145.9);
//     (0, 0) @PIN(terminal="VINP");
//     (2.2, 0) @TEXT("VINP", size=3.8, halign="start", valign="middle");
//     (0, -16) @PIN(terminal="VINN");
//     (2.2, -16) @TEXT("VINN", size=3.8, halign="start", valign="middle");
//     (0, -40) @PIN(terminal="VDD");
//     (2.2, -40) @TEXT("VDD", size=3.8, halign="start", valign="middle");
//     (0, -48) @PIN(terminal="VSS");
//     (2.2, -48) @TEXT("VSS", size=3.8, halign="start", valign="middle");
//     (0, -56) @PIN(terminal="VCM");
//     (2.2, -56) @TEXT("VCM", size=3.8, halign="start", valign="middle");
//     (0, -64) @PIN(terminal="VREFP");
//     (2.2, -64) @TEXT("VREFP", size=3.8, halign="start", valign="middle");
//     (0, -72) @PIN(terminal="VREFN");
//     (2.2, -72) @TEXT("VREFN", size=3.8, halign="start", valign="middle");
//     (0, -88) @PIN(terminal="IB_A");
//     (2.2, -88) @TEXT("IB\_A", size=3.8, halign="start", valign="middle");
//     (0, -96) @PIN(terminal="IB_B");
//     (2.2, -96) @TEXT("IB\_B", size=3.8, halign="start", valign="middle");
//     (86.4, 0) @PIN(terminal=["CODE_11", "CODE_10", "CODE_9", "CODE_8", "CODE_7", "CODE_6", "CODE_5", "CODE_4", "CODE_3", "CODE_2", "CODE_1", "CODE_0"]);
//     (84.2, 0) @TEXT("CODE<11:0>", size=3.8, halign="end", valign="middle");
//     (86.4, -8) @PIN(terminal="RECON");
//     (84.2, -8) @TEXT("RECON", size=3.8, halign="end", valign="middle");
//     (86.4, -16) @PIN(terminal="VALID");
//     (84.2, -16) @TEXT("VALID", size=3.8, halign="end", valign="middle");
//     (86.4, -24) @PIN(terminal="OVERFLOW");
//     (84.2, -24) @TEXT("OVERFLOW", size=3.8, halign="end", valign="middle");
//     (86.4, -32) @PIN(terminal="CHANNEL");
//     (84.2, -32) @TEXT("CHANNEL", size=3.8, halign="end", valign="middle");
//     (86.4, -48) @PIN(terminal="ROP");
//     (84.2, -48) @TEXT("ROP", size=3.8, halign="end", valign="middle");
//     (86.4, -56) @PIN(terminal="RON");
//     (84.2, -56) @TEXT("RON", size=3.8, halign="end", valign="middle");
//     (86.4, -72) @PIN(terminal=["D_14", "D_13", "D_12", "D_11", "D_10", "D_9", "D_8", "D_7", "D_6", "D_5", "D_4", "D_3", "D_2", "D_1", "D_0"]);
//     (84.2, -72) @TEXT("D<14:0>", size=3.8, halign="end", valign="middle");
//     (86.4, -80) @PIN(terminal=["BIN_3", "BIN_2", "BIN_1", "BIN_0"]);
//     (84.2, -80) @TEXT("BIN<3:0>", size=3.8, halign="end", valign="middle");
//     (86.4, -96) @PIN(terminal="TRACK");
//     (84.2, -96) @TEXT("TRACK", size=3.8, halign="end", valign="middle");
//     (86.4, -104) @PIN(terminal="AMP");
//     (84.2, -104) @TEXT("AMP", size=3.8, halign="end", valign="middle");
//     (86.4, -112) @PIN(terminal="TA");
//     (84.2, -112) @TEXT("TA", size=3.8, halign="end", valign="middle");
//     (86.4, -120) @PIN(terminal="TB");
//     (84.2, -120) @TEXT("TB", size=3.8, halign="end", valign="middle");
//     (86.4, -128) @PIN(terminal="DA");
//     (84.2, -128) @TEXT("DA", size=3.8, halign="end", valign="middle");
//     (86.4, -136) @PIN(terminal="DB");
//     (84.2, -136) @TEXT("DB", size=3.8, halign="end", valign="middle")
//   };
//   # @SET-SYMBOL %block_symbol;
//   #"CH_AP" @SET-SYMBOL $CAPACITOR;
//   #"CH_AP" @PLACE(368, 51) => @ORIENT("R180");
//   #"CPROBE6" @SET-SYMBOL $CAPACITOR;
//   #"CPROBE6" @PLACE(491, 8) => @ORIENT("R90");
//   #"S_BN" @PLACE(336, -80) => @ORIENT("R0");
//   %symbol_0 = @DEFINE-SYMBOL(box=[0, -164.8, 70.4, 4.8]) {
//     @RECTANGLE {(0, -164.8) (70.4, 4.8)};
//     (35.2, -76.8) @TEXT("C12 = 256 K4", size=4.2, halign="middle", valign="middle");
//     (35.2, 10.4) @TEXT("ALIGN + MERGE", size=4.6, halign="middle", valign="middle");
//     (35.2, -84.8) @TEXT("+ Q9 - 128", size=4.2, halign="middle", valign="middle");
//     (35.2, -97.6) @TEXT("1 overlap bit", size=4.2, halign="middle", valign="middle");
//     ? @TEXT("${name}", size=3.8, halign="middle", valign="middle", key="name") => @PLACE(35.2, -169.9);
//     (70.4, -16) @PIN(terminal=46);
//     (68.2, -16) @TEXT("RECON", size=3.8, halign="end", valign="middle");
//     (70.4, -32) @PIN(terminal=43);
//     (68.2, -32) @TEXT("VALID", size=3.8, halign="end", valign="middle");
//     (70.4, -160) @PIN(terminal=48);
//     (68.2, -160) @TEXT("VSS", size=3.8, halign="end", valign="middle");
//     (70.4, -152) @PIN(terminal=47);
//     (68.2, -152) @TEXT("VDD", size=3.8, halign="end", valign="middle");
//     (70.4, -64) @PIN(terminal=45);
//     (68.2, -64) @TEXT("OVF", size=3.8, halign="end", valign="middle");
//     (70.4, -48) @PIN(terminal=44);
//     (68.2, -48) @TEXT("CHANNEL", size=3.8, halign="end", valign="middle");
//     (0, -131.2) @PIN(terminal=28);
//     (2.2, -131.2) @TEXT("DB", size=3.8, halign="start", valign="middle");
//     (0, -139.2) @PIN(terminal=30);
//     (2.2, -139.2) @TEXT("OFB", size=3.8, halign="start", valign="middle");
//     (70.4, 0) @PIN(terminal=[31, 32, 33, 34, 35, 36, 37, 38, 39, 40, 41, 42]);
//     (68.2, 0) @TEXT("CODE<11:0>", size=3.8, halign="end", valign="middle");
//     (0, -123.2) @PIN(terminal=[23, 24, 25, 26]);
//     (2.2, -123.2) @TEXT("KB<3:0>", size=3.8, halign="start", valign="middle");
//     (0, -115.2) @PIN(terminal=[10, 11, 12, 13, 14, 15, 16, 17, 18]);
//     (2.2, -115.2) @TEXT("QB<8:0>", size=3.8, halign="start", valign="middle");
//     (0, -16) @PIN(terminal=27);
//     (2.2, -16) @TEXT("DA", size=3.8, halign="start", valign="middle");
//     (0, -24) @PIN(terminal=29);
//     (2.2, -24) @TEXT("OFA", size=3.8, halign="start", valign="middle");
//     (0, -8) @PIN(terminal=[19, 20, 21, 22]);
//     (2.2, -8) @TEXT("KA<3:0>", size=3.8, halign="start", valign="middle");
//     (0, 0) @PIN(terminal=[1, 2, 3, 4, 5, 6, 7, 8, 9]);
//     (2.2, 0) @TEXT("QA<8:0>", size=3.8, halign="start", valign="middle")
//   };
//   #"XMERGE" @SET-SYMBOL %symbol_0;
//   #"XMERGE" @PLACE(531.2, 48) => @ORIENT("R0");
//   #"XSARA" @PLACE(400, 48) => @ORIENT("R0");
//   #"CPROBE2" @SET-SYMBOL $CAPACITOR;
//   #"CPROBE2" @PLACE(491, 0) => @ORIENT("R90");
//   #"XSARB" @PLACE(400, -67.2) => @ORIENT("R0");
//   %bundle_0 = {#"C_D_14" #"C_D_13" #"C_D_12" #"C_D_11" #"C_D_10" #"C_D_9" #"C_D_8" #"C_D_7" #"C_D_6" #"C_D_5" #"C_D_4" #"C_D_3" #"C_D_2" #"C_D_1" #"C_D_0"} @BUNDLE;
//   %bundle_0 @SET-SYMBOL $CAPACITOR;
//   %bundle_0 @PLACE(48, -163) => @ORIENT("R0");
//   %bundle_0 @TEXT("C\_D<14:0>", key="name");
//   #"XRA" @PLACE(224, 48) => @ORIENT("R0");
//   #"CPROBE1" @SET-SYMBOL $CAPACITOR;
//   #"CPROBE1" @PLACE(491, -123.2) => @ORIENT("R90");
//   #"CH_BP" @SET-SYMBOL $CAPACITOR;
//   #"CH_BP" @PLACE(368, -64.2) => @ORIENT("R180");
//   #"CPROBE7" @SET-SYMBOL $CAPACITOR;
//   #"CPROBE7" @PLACE(491, -107.2) => @ORIENT("R90");
//   %symbol_1 = @DEFINE-SYMBOL(box=[0, -56, 57.6, 4.8]) {
//     @RECTANGLE {(0, -56) (57.6, 4.8)};
//     (28.8, 10.4) @TEXT("COARSE DAC", size=4.6, halign="middle", valign="middle");
//     ? @TEXT("${name}", size=3.8, halign="middle", valign="middle", key="name") => @PLACE(28.8, -61.1);
//     (0, -8) @PIN(terminal=23);
//     (2.2, -8) @TEXT("VREFP", size=3.8, halign="start", valign="middle");
//     (0, -16) @PIN(terminal=24);
//     (2.2, -16) @TEXT("VREFN", size=3.8, halign="start", valign="middle");
//     (0, -24) @PIN(terminal=22);
//     (2.2, -24) @TEXT("VCM", size=3.8, halign="start", valign="middle");
//     (0, -32) @PIN(terminal=25);
//     (2.2, -32) @TEXT("VDD", size=3.8, halign="start", valign="middle");
//     (0, -40) @PIN(terminal=26);
//     (2.2, -40) @TEXT("VSS", size=3.8, halign="start", valign="middle");
//     (57.6, 0) @PIN(terminal=16);
//     (55.4, 0) @TEXT("VP", size=3.8, halign="end", valign="middle");
//     (57.6, -12.8) @PIN(terminal=17);
//     (55.4, -12.8) @TEXT("VN", size=3.8, halign="end", valign="middle");
//     (57.6, -51.2) @PIN(terminal=[18, 19, 20, 21]);
//     (55.4, -51.2) @TEXT("K<3:0>", size=3.8, halign="end", valign="middle");
//     (0, 0) @PIN(terminal=[1, 2, 3, 4, 5, 6, 7, 8, 9, 10, 11, 12, 13, 14, 15]);
//     (2.2, 0) @TEXT("D<14:0>", size=3.8, halign="start", valign="middle")
//   };
//   #"XDAC" @SET-SYMBOL %symbol_1;
//   #"XDAC" @PLACE(144, 0) => @ORIENT("R0");
//   #"CH_AN" @SET-SYMBOL $CAPACITOR;
//   #"CH_AN" @PLACE(368, 32.2) => @ORIENT("R0");
//   #"CPROBE5" @SET-SYMBOL $CAPACITOR;
//   #"CPROBE5" @PLACE(491, -131.2) => @ORIENT("R90");
//   #"S_AN" @PLACE(336, 35.2) => @ORIENT("R0");
//   #"CH_BN" @SET-SYMBOL $CAPACITOR;
//   #"CH_BN" @PLACE(368, -83) => @ORIENT("R0");
//   %bundle_1 = {#"C_DP_14" #"C_DP_13" #"C_DP_12" #"C_DP_11" #"C_DP_10" #"C_DP_9" #"C_DP_8" #"C_DP_7" #"C_DP_6" #"C_DP_5" #"C_DP_4" #"C_DP_3" #"C_DP_2" #"C_DP_1" #"C_DP_0"} @BUNDLE;
//   %bundle_1 @SET-SYMBOL $CAPACITOR;
//   %bundle_1 @PLACE(83.2, -163) => @ORIENT("R0");
//   %bundle_1 @TEXT("C\_DP<14:0>", key="name");
//   #"CPROBE3" @SET-SYMBOL $CAPACITOR;
//   #"CPROBE3" @PLACE(491, -115.2) => @ORIENT("R90");
//   #"CPROBE4" @SET-SYMBOL $CAPACITOR;
//   #"CPROBE4" @PLACE(491, -16) => @ORIENT("R90");
//   #"XFLASH" @PLACE(48, 0) => @ORIENT("R0");
//   #"S_BP" @PLACE(336, -67.2) => @ORIENT("R0");
//   %symbol_2 = @DEFINE-SYMBOL(box=[0, -68.8, 70.4, 4.8]) {
//     @RECTANGLE {(0, -68.8) (70.4, 4.8)};
//     (35.2, 10.4) @TEXT("CLOCK PHASES", size=4.6, halign="middle", valign="middle");
//     ? @TEXT("${name}", size=3.8, halign="middle", valign="middle", key="name") => @PLACE(35.2, -73.9);
//     (0, 0) @PIN(terminal=10);
//     (2.2, 0) @TEXT("VDD", size=3.8, halign="start", valign="middle");
//     (0, -8) @PIN(terminal=11);
//     (2.2, -8) @TEXT("VSS", size=3.8, halign="start", valign="middle");
//     (70.4, 0) @PIN(terminal=1);
//     (68.2, 0) @TEXT("TRACK", size=3.8, halign="end", valign="middle");
//     (70.4, -8) @PIN(terminal=6);
//     (68.2, -8) @TEXT("PHI1EN", size=3.8, halign="end", valign="middle");
//     (70.4, -16) @PIN(terminal=7);
//     (68.2, -16) @TEXT("PHI1N", size=3.8, halign="end", valign="middle");
//     (70.4, -24) @PIN(terminal=8);
//     (68.2, -24) @TEXT("PHI2P", size=3.8, halign="end", valign="middle");
//     (70.4, -32) @PIN(terminal=9);
//     (68.2, -32) @TEXT("PHI2N", size=3.8, halign="end", valign="middle");
//     (70.4, -40) @PIN(terminal=2);
//     (68.2, -40) @TEXT("AMP", size=3.8, halign="end", valign="middle");
//     (70.4, -48) @PIN(terminal=3);
//     (68.2, -48) @TEXT("RESET", size=3.8, halign="end", valign="middle");
//     (70.4, -56) @PIN(terminal=4);
//     (68.2, -56) @TEXT("TA", size=3.8, halign="end", valign="middle");
//     (70.4, -64) @PIN(terminal=5);
//     (68.2, -64) @TEXT("TB", size=3.8, halign="end", valign="middle")
//   };
//   #"XCLK" @SET-SYMBOL %symbol_2;
//   #"XCLK" @PLACE(208, -112) => @ORIENT("R0");
//   #"S_AP" @PLACE(336, 48) => @ORIENT("R0");
//   #"CPROBE0" @SET-SYMBOL $CAPACITOR;
//   #"CPROBE0" @PLACE(491, -8) => @ORIENT("R90");
//   %bundle_2 = {#"C_DN_14" #"C_DN_13" #"C_DN_12" #"C_DN_11" #"C_DN_10" #"C_DN_9" #"C_DN_8" #"C_DN_7" #"C_DN_6" #"C_DN_5" #"C_DN_4" #"C_DN_3" #"C_DN_2" #"C_DN_1" #"C_DN_0"} @BUNDLE;
//   %bundle_2 @SET-SYMBOL $CAPACITOR;
//   %bundle_2 @PLACE(118.4, -163) => @ORIENT("R0");
//   %bundle_2 @TEXT("C\_DN<14:0>", key="name");
//   %bundle_3 = {#"C_BIN_3" #"C_BIN_2" #"C_BIN_1" #"C_BIN_0"} @BUNDLE;
//   %bundle_3 @SET-SYMBOL $CAPACITOR;
//   %bundle_3 @PLACE(153.6, -163) => @ORIENT("R0");
//   %bundle_3 @TEXT("C\_BIN<3:0>", key="name");
//   %output_port_symbol = @DEFINE-SYMBOL(box=[0, -1, 2, 1]) {
//       @LINE(fill="linecolor", linestyle="none") {(0, -0.9) (0, 0.9) (1.1, 0.9) (2, 0) (1.1, -0.9) (0, -0.9)};
//       (0, 0) @PIN(terminal=1, direction="left");
//       ? @TEXT("${name}", key="name", halign="middle") => @PLACE(1, 1.6)
//     };
//   %port_0 = $IO_PORT @ATTACH &"OVERFLOW" => @PLACE(627.2, -16) => @ORIENT("R0");
//   %port_0 @SET-SYMBOL %output_port_symbol;
//   %port_0 @TEXT("OVERFLOW", key="name");
//   %port_1 = $IO_PORT @ATTACH &"CHANNEL" => @PLACE(627.2, 0) => @ORIENT("R0");
//   %port_1 @SET-SYMBOL %output_port_symbol;
//   %port_1 @TEXT("CHANNEL", key="name");
//   %port_2 = $IO_PORT @ATTACH &"VALID" => @PLACE(627.2, 16) => @ORIENT("R0");
//   %port_2 @SET-SYMBOL %output_port_symbol;
//   %port_2 @TEXT("VALID", key="name");
//   %port_3 = $IO_PORT @ATTACH &"RECON" => @PLACE(627.2, 32) => @ORIENT("R0");
//   %port_3 @SET-SYMBOL %output_port_symbol;
//   %port_3 @TEXT("RECON", key="name");
//   %bus_port_type_4 = @DEFINE(roles=[["p", "net"], ["p1", "net"], ["p2", "net"], ["p3", "net"], ["p4", "net"], ["p5", "net"], ["p6", "net"], ["p7", "net"], ["p8", "net"], ["p9", "net"], ["p10", "net"], ["p11", "net"]]) {};
//   %bus_port_type_4_symbol = @DEFINE-SYMBOL {(0, 0) @PIN(terminal=[1, 2, 3, 4, 5, 6, 7, 8, 9, 10, 11, 12])};
//   {&"CODE_11" &"CODE_10" &"CODE_9" &"CODE_8" &"CODE_7" &"CODE_6" &"CODE_5" &"CODE_4" &"CODE_3" &"CODE_2" &"CODE_1" &"CODE_0"} @REMOVE-FROM $PORT_FILL_SET;
//   %port_4 = %bus_port_type_4 @ATTACH &"CODE_11" &"CODE_10" &"CODE_9" &"CODE_8" &"CODE_7" &"CODE_6" &"CODE_5" &"CODE_4" &"CODE_3" &"CODE_2" &"CODE_1" &"CODE_0" => @PLACE(627.2, 48) => @ORIENT("R0");
//   %port_4 @SET-SYMBOL %bus_port_type_4_symbol;
//   %port_4_marker = $IO_PORT @ATTACH &"CODE_11" => @PLACE(627.2, 48) => @ORIENT("R0");
//   %port_4_marker @SET-SYMBOL %output_port_symbol;
//   %port_4_marker @TEXT("CODE<11:0>", key="name");
//   %port_5 = $IO_PORT @ATTACH &"TRACK" => @PLACE(304, -112) => @ORIENT("R0");
//   %port_5 @SET-SYMBOL %output_port_symbol;
//   %port_5 @TEXT("TRACK", key="name");
//   %port_6 = $IO_PORT @ATTACH &"AMP" => @PLACE(304, -152) => @ORIENT("R0");
//   %port_6 @SET-SYMBOL %output_port_symbol;
//   %port_6 @TEXT("AMP", key="name");
//   %port_7 = $IO_PORT @ATTACH &"TA" => @PLACE(304, -168) => @ORIENT("R0");
//   %port_7 @SET-SYMBOL %output_port_symbol;
//   %port_7 @TEXT("TA", key="name");
//   %port_8 = $IO_PORT @ATTACH &"TB" => @PLACE(304, -176) => @ORIENT("R0");
//   %port_8 @SET-SYMBOL %output_port_symbol;
//   %port_8 @TEXT("TB", key="name");
//   %bus_port_type_9 = @DEFINE(roles=[["p", "net"], ["p1", "net"], ["p2", "net"], ["p3", "net"]]) {};
//   %bus_port_type_9_symbol = @DEFINE-SYMBOL {(0, 0) @PIN(terminal=[1, 2, 3, 4])};
//   {&"BIN_3" &"BIN_2" &"BIN_1" &"BIN_0"} @REMOVE-FROM $PORT_FILL_SET;
//   %port_9 = %bus_port_type_9 @ATTACH &"BIN_3" &"BIN_2" &"BIN_1" &"BIN_0" => @PLACE(153.6, -147.2) => @ORIENT("R0");
//   %port_9 @SET-SYMBOL %bus_port_type_9_symbol;
//   %port_9_marker = $IO_PORT @ATTACH &"BIN_3" => @PLACE(153.6, -147.2) => @ORIENT("R0");
//   %port_9_marker @SET-SYMBOL %output_port_symbol;
//   %port_9_marker @TEXT("BIN<3:0>", key="name");
//   %bus_port_type_10 = @DEFINE(roles=[["p", "net"], ["p1", "net"], ["p2", "net"], ["p3", "net"], ["p4", "net"], ["p5", "net"], ["p6", "net"], ["p7", "net"], ["p8", "net"], ["p9", "net"], ["p10", "net"], ["p11", "net"], ["p12", "net"], ["p13", "net"], ["p14", "net"]]) {};
//   %bus_port_type_10_symbol = @DEFINE-SYMBOL {(0, 0) @PIN(terminal=[1, 2, 3, 4, 5, 6, 7, 8, 9, 10, 11, 12, 13, 14, 15])};
//   {&"D_14" &"D_13" &"D_12" &"D_11" &"D_10" &"D_9" &"D_8" &"D_7" &"D_6" &"D_5" &"D_4" &"D_3" &"D_2" &"D_1" &"D_0"} @REMOVE-FROM $PORT_FILL_SET;
//   %port_10 = %bus_port_type_10 @ATTACH &"D_14" &"D_13" &"D_12" &"D_11" &"D_10" &"D_9" &"D_8" &"D_7" &"D_6" &"D_5" &"D_4" &"D_3" &"D_2" &"D_1" &"D_0" => @PLACE(48, -147.2) => @ORIENT("R0");
//   %port_10 @SET-SYMBOL %bus_port_type_10_symbol;
//   %port_10_marker = $IO_PORT @ATTACH &"D_14" => @PLACE(48, -147.2) => @ORIENT("R0");
//   %port_10_marker @SET-SYMBOL %output_port_symbol;
//   %port_10_marker @TEXT("D<14:0>", key="name");
//   %input_port_symbol = @DEFINE-SYMBOL(box=[-2, -1, 0, 1]) {
//       @LINE(fill="linecolor", linestyle="none") {(-2, -0.9) (-2, 0.9) (-0.9, 0.9) (0, 0) (-0.9, -0.9) (-2, -0.9)};
//       (0, 0) @PIN(terminal=1, direction="right");
//       ? @TEXT("${name}", key="name", halign="middle") => @PLACE(-1, 1.6)
//     };
//   %port_11 = $IO_PORT @ATTACH &"IB_B" => @PLACE(160, -107.2) => @ORIENT("R0");
//   %port_11 @SET-SYMBOL %input_port_symbol;
//   %port_11 @TEXT("IB\_B", key="name");
//   %port_12 = $IO_PORT @ATTACH &"IB_A" => @PLACE(160, -97.6) => @ORIENT("R0");
//   %port_12 @SET-SYMBOL %input_port_symbol;
//   %port_12 @TEXT("IB\_A", key="name");
//   %port_13 = $IO_PORT @ATTACH &"VREFN" => @PLACE(8, -91.2) => @ORIENT("R0");
//   %port_13 @SET-SYMBOL %input_port_symbol;
//   %port_13 @TEXT("VREFN", key="name");
//   %port_14 = $IO_PORT @ATTACH &"VREFP" => @PLACE(8, -83.2) => @ORIENT("R0");
//   %port_14 @SET-SYMBOL %input_port_symbol;
//   %port_14 @TEXT("VREFP", key="name");
//   %port_15 = $IO_PORT @ATTACH &"VCM" => @PLACE(8, -99.2) => @ORIENT("R0");
//   %port_15 @SET-SYMBOL %input_port_symbol;
//   %port_15 @TEXT("VCM", key="name");
//   %port_16 = $IO_PORT @ATTACH &"VSS" => @PLACE(8, -115.2) => @ORIENT("R0");
//   %port_16 @SET-SYMBOL %input_port_symbol;
//   %port_16 @TEXT("VSS", key="name");
//   %port_17 = $IO_PORT @ATTACH &"VDD" => @PLACE(8, -107.2) => @ORIENT("R0");
//   %port_17 @SET-SYMBOL %input_port_symbol;
//   %port_17 @TEXT("VDD", key="name");
//   %port_18 = $IO_PORT @ATTACH &"RON" => @PLACE(320, 64) => @ORIENT("R0");
//   %port_18 @SET-SYMBOL %output_port_symbol;
//   %port_18 @TEXT("RON", key="name");
//   %port_19 = $IO_PORT @ATTACH &"ROP" => @PLACE(310.4, 72) => @ORIENT("R0");
//   %port_19 @SET-SYMBOL %output_port_symbol;
//   %port_19 @TEXT("ROP", key="name");
//   %port_20 = $IO_PORT @ATTACH &"DB" => @PLACE(508.8, -83.2) => @ORIENT("R0");
//   %port_20 @SET-SYMBOL %output_port_symbol;
//   %port_20 @TEXT("DB", key="name");
//   %port_21 = $IO_PORT @ATTACH &"DA" => @PLACE(508.8, 32) => @ORIENT("R0");
//   %port_21 @SET-SYMBOL %output_port_symbol;
//   %port_21 @TEXT("DA", key="name");
//   %port_22 = $IO_PORT @ATTACH &"VINN" => @PLACE(-8, 35.2) => @ORIENT("R0");
//   %port_22 @SET-SYMBOL %input_port_symbol;
//   %port_22 @TEXT("VINN", key="name");
//   %port_23 = $IO_PORT @ATTACH &"VINP" => @PLACE(-8, 48) => @ORIENT("R0");
//   %port_23 @SET-SYMBOL %input_port_symbol;
//   %port_23 @TEXT("VINP", key="name");
//   %wire_0 = &"VHB" @WIRE(mode="straight") {#"XSARB":26 #"CPROBE3":1};
//   %wire_0 @TEXT("VHB", size=3.5, halign="middle", valign="baseline") => @PLACE(480, -114.3);
//   %wire_1 = &"VHA" @WIRE(mode="straight") {#"XSARA":26 #"CPROBE2":1};
//   %wire_1 @TEXT("VHA", size=3.5, halign="middle", valign="baseline") => @PLACE(480, 0.9);
//   %wire_2 = &"VDACB" @WIRE(mode="straight") {#"XSARB":24 #"CPROBE1":1};
//   %wire_2 @TEXT("VDACB", size=3.5, halign="middle", valign="baseline") => @PLACE(480, -122.3);
//   %wire_3 = &"VDACA" @WIRE(mode="straight") {#"XSARA":24 #"CPROBE0":1};
//   %wire_3 @TEXT("VDACA", size=3.5, halign="middle", valign="baseline") => @PLACE(480, -7.1);
//   %wire_4 = &"STEPB" @WIRE(mode="straight") {#"XSARB":21 #"CPROBE5":1};
//   %wire_4 @TEXT("STEPB", size=3.5, halign="middle", valign="baseline") => @PLACE(480, -130.3);
//   %wire_5 = &"STEPA" @WIRE(mode="straight") {#"XSARA":21 #"CPROBE4":1};
//   %wire_5 @TEXT("STEPA", size=3.5, halign="middle", valign="baseline") => @PLACE(480, -15.1);
//   %wire_6 = {&"QB_8" &"QB_7" &"QB_6" &"QB_5" &"QB_4" &"QB_3" &"QB_2" &"QB_1" &"QB_0"} @WIRE(mode="straight") {#"XSARB":12 #"XMERGE":10};
//   %wire_6 @TEXT("QB<8:0>", size=3.5, halign="middle", valign="baseline") => @PLACE(501.6, -66.3);
//   %p0 = (288.8, -136);
//   %wire_7 = &"PHI2P" @WIRE(mode="straight") {#"XCLK":8 %p0};
//   %p1 = (37.6, -44.8);
//   %wire_8 = &"PHI2P" @WIRE(mode="straight") {%p1 #"XFLASH":55};
//   %wire_8 @TEXT("PHI2P", size=3.2, halign="end", valign="middle") => @PLACE(36, -44.8);
//   %wire_7 @TEXT("PHI2P", size=3.2, halign="start", valign="middle") => @PLACE(290.4, -136);
//   %p2 = (288.8, -144);
//   %wire_9 = &"PHI2N" @WIRE(mode="straight") {#"XCLK":9 %p2};
//   %p3 = (37.6, -52.8);
//   %wire_10 = &"PHI2N" @WIRE(mode="straight") {%p3 #"XFLASH":54};
//   %wire_10 @TEXT("PHI2N", size=3.2, halign="end", valign="middle") => @PLACE(36, -52.8);
//   %wire_9 @TEXT("PHI2N", size=3.2, halign="start", valign="middle") => @PLACE(290.4, -144);
//   %p4 = (288.8, -128);
//   %wire_11 = &"PHI1N" @WIRE(mode="straight") {#"XCLK":7 %p4};
//   %p5 = (37.6, -36.8);
//   %wire_12 = &"PHI1N" @WIRE(mode="straight") {%p5 #"XFLASH":53};
//   %wire_12 @TEXT("PHI1N", size=3.2, halign="end", valign="middle") => @PLACE(36, -36.8);
//   %wire_11 @TEXT("PHI1N", size=3.2, halign="start", valign="middle") => @PLACE(290.4, -128);
//   %p6 = (288.8, -120);
//   %wire_13 = &"PHI1EN" @WIRE(mode="straight") {#"XCLK":6 %p6};
//   %p7 = (37.6, -28.8);
//   %wire_14 = &"PHI1EN" @WIRE(mode="straight") {%p7 #"XFLASH":52};
//   %wire_14 @TEXT("PHI1EN", size=3.2, halign="end", valign="middle") => @PLACE(36, -28.8);
//   %wire_13 @TEXT("PHI1EN", size=3.2, halign="start", valign="middle") => @PLACE(290.4, -120);
//   %wire_15 = &"HBP" @WIRE(mode="straight") {#"S_BP":2 #"CH_BP":1};
//   %wire_16 = &"HBP" @WIRE(mode="straight") {#"CH_BP":1 #"XSARB":28};
//   %wire_16 @TEXT("HBP", size=3.5, halign="middle", valign="baseline") => @PLACE(384, -66.3);
//   %wire_17 = &"HBN" @WIRE(mode="straight") {#"S_BN":2 #"CH_BN":1};
//   %wire_18 = &"HBN" @WIRE(mode="straight") {#"CH_BN":1 #"XSARB":27};
//   %wire_18 @TEXT("HBN", size=3.5, halign="middle", valign="baseline") => @PLACE(384, -79.1);
//   %wire_19 = &"HAP" @WIRE(mode="straight") {#"S_AP":2 #"CH_AP":1};
//   %wire_20 = &"HAP" @WIRE(mode="straight") {#"CH_AP":1 #"XSARA":28};
//   %wire_20 @TEXT("HAP", size=3.5, halign="middle", valign="baseline") => @PLACE(384, 48.9);
//   %wire_21 = &"HAN" @WIRE(mode="straight") {#"S_AN":2 #"CH_AN":1};
//   %wire_22 = &"HAN" @WIRE(mode="straight") {#"CH_AN":1 #"XSARA":27};
//   %wire_22 @TEXT("HAN", size=3.5, halign="middle", valign="baseline") => @PLACE(384, 36.1);
//   %wire_23 = &"BUSYB" @WIRE(mode="straight") {#"XSARB":1 #"CPROBE7":1};
//   %wire_23 @TEXT("BUSYB", size=3.5, halign="middle", valign="baseline") => @PLACE(480, -106.3);
//   %wire_24 = &"BUSYA" @WIRE(mode="straight") {#"XSARA":1 #"CPROBE6":1};
//   %wire_24 @TEXT("BUSYA", size=3.5, halign="middle", valign="baseline") => @PLACE(480, 8.9);
//   %p8 = (212, -51.2);
//   %wire_25 = {&"K_3" &"K_2" &"K_1" &"K_0"} @WIRE(mode="straight") {#"XDAC":18 %p8};
//   %p9 = (389.6, -100.8);
//   %wire_26 = {&"K_3" &"K_2" &"K_1" &"K_0"} @WIRE(mode="straight") {%p9 #"XSARB":3};
//   %p10 = (389.6, 14.4);
//   %wire_27 = {&"K_3" &"K_2" &"K_1" &"K_0"} @WIRE(mode="straight") {%p10 #"XSARA":3};
//   %wire_27 @TEXT("K<3:0>", size=3.2, halign="end", valign="middle") => @PLACE(388, 14.4);
//   %wire_26 @TEXT("K<3:0>", size=3.2, halign="end", valign="middle") => @PLACE(388, -100.8);
//   %wire_25 @TEXT("K<3:0>", size=3.2, halign="start", valign="middle") => @PLACE(213.6, -51.2);
//   %p11 = (510, -83.2);
//   %wire_28 = &"DB" @WIRE(mode="straight") {#"XSARB":2 %port_20:p %p11};
//   %wire_29 = &"DB" @WIRE(mode="straight") {%p11 #"XMERGE":28};
//   %p12 = (510, 32);
//   %wire_30 = &"DA" @WIRE(mode="straight") {#"XSARA":2 %port_21:p %p12};
//   %wire_31 = &"DA" @WIRE(mode="straight") {%p12 #"XMERGE":27};
//   %wire_32 = &"TB" @WIRE(mode="straight") {#"XCLK":5 %port_8:p};
//   %p13 = (340, -71.6);
//   %wire_33 = &"TB" @WIRE(mode="straight") {#"S_BN":3 %p13};
//   %p14 = (340, -58.8);
//   %wire_34 = &"TB" @WIRE(mode="straight") {#"S_BP":3 %p14};
//   %p15 = (389.6, -92.8);
//   %wire_35 = &"TB" @WIRE(mode="straight") {%p15 #"XSARB":22};
//   %wire_35 @TEXT("TB", size=3.2, halign="end", valign="middle") => @PLACE(388, -92.8);
//   %wire_34 @TEXT("TB", size=3.2, halign="middle", valign="baseline") => @PLACE(340, -57.5);
//   %wire_33 @TEXT("TB", size=3.2, halign="middle", valign="baseline") => @PLACE(340, -70.3);
//   %wire_36 = &"TA" @WIRE(mode="straight") {#"XCLK":4 %port_7:p};
//   %p16 = (340, 43.6);
//   %wire_37 = &"TA" @WIRE(mode="straight") {#"S_AN":3 %p16};
//   %p17 = (340, 56.4);
//   %wire_38 = &"TA" @WIRE(mode="straight") {#"S_AP":3 %p17};
//   %p18 = (389.6, 22.4);
//   %wire_39 = &"TA" @WIRE(mode="straight") {%p18 #"XSARA":22};
//   %wire_39 @TEXT("TA", size=3.2, halign="end", valign="middle") => @PLACE(388, 22.4);
//   %wire_38 @TEXT("TA", size=3.2, halign="middle", valign="baseline") => @PLACE(340, 57.7);
//   %wire_37 @TEXT("TA", size=3.2, halign="middle", valign="baseline") => @PLACE(340, 44.9);
//   %wire_40 = &"AMP" @WIRE(mode="straight") {#"XCLK":2 %port_6:p};
//   %p19 = (218.4, -32);
//   %wire_41 = &"AMP" @WIRE(mode="straight") {%p19 #"XRA":1};
//   %wire_41 @TEXT("AMP", size=3.2, halign="end", valign="middle") => @PLACE(216.8, -32);
//   %wire_42 = &"VALID" @WIRE(mode="straight") {#"XMERGE":43 %port_2:p};
//   %wire_43 = {&"QA_8" &"QA_7" &"QA_6" &"QA_5" &"QA_4" &"QA_3" &"QA_2" &"QA_1" &"QA_0"} @WIRE(mode="straight") {#"XSARA":12 #"XMERGE":1};
//   %wire_43 @TEXT("QA<8:0>", size=3.5, halign="middle", valign="baseline") => @PLACE(501.6, 48.9);
//   %p20 = (83.2, -153.6);
//   %wire_44 = {&"DP_14" &"DP_13" &"DP_12" &"DP_11" &"DP_10" &"DP_9" &"DP_8" &"DP_7" &"DP_6" &"DP_5" &"DP_4" &"DP_3" &"DP_2" &"DP_1" &"DP_0"} @WIRE(mode="straight") {%bundle_1:1 %p20};
//   %p21 = (123.2, -59.2);
//   %wire_45 = {&"DP_14" &"DP_13" &"DP_12" &"DP_11" &"DP_10" &"DP_9" &"DP_8" &"DP_7" &"DP_6" &"DP_5" &"DP_4" &"DP_3" &"DP_2" &"DP_1" &"DP_0"} @WIRE(mode="straight") {#"XFLASH":35 %p21};
//   %wire_45 @TEXT("DP<14:0>", size=3.2, halign="start", valign="middle") => @PLACE(124.8, -59.2);
//   %wire_44 @TEXT("DP<14:0>", size=3.2, halign="middle", valign="baseline") => @PLACE(83.2, -152.3);
//   %p22 = (118.4, -153.6);
//   %wire_46 = {&"DN_14" &"DN_13" &"DN_12" &"DN_11" &"DN_10" &"DN_9" &"DN_8" &"DN_7" &"DN_6" &"DN_5" &"DN_4" &"DN_3" &"DN_2" &"DN_1" &"DN_0"} @WIRE(mode="straight") {%bundle_2:1 %p22};
//   %p23 = (123.2, -67.2);
//   %wire_47 = {&"DN_14" &"DN_13" &"DN_12" &"DN_11" &"DN_10" &"DN_9" &"DN_8" &"DN_7" &"DN_6" &"DN_5" &"DN_4" &"DN_3" &"DN_2" &"DN_1" &"DN_0"} @WIRE(mode="straight") {#"XFLASH":20 %p23};
//   %wire_47 @TEXT("DN<14:0>", size=3.2, halign="start", valign="middle") => @PLACE(124.8, -67.2);
//   %wire_46 @TEXT("DN<14:0>", size=3.2, halign="middle", valign="baseline") => @PLACE(118.4, -152.3);
//   %p24 = (153.6, -172.4);
//   %wire_48 = &"VSS" @WIRE(mode="straight") {%p24 %bundle_3:2};
//   %wire_48 @TEXT("<*4>VSS", size=3.2, halign="middle", valign="top") => @PLACE(153.6, -173.7);
//   %p25 = (118.4, -172.4);
//   %wire_49 = &"VSS" @WIRE(mode="straight") {%p25 %bundle_2:2};
//   %p26 = (83.2, -172.4);
//   %wire_50 = &"VSS" @WIRE(mode="straight") {%p26 %bundle_1:2};
//   %p27 = (48, -172.4);
//   %wire_51 = &"VSS" @WIRE(mode="straight") {%p27 %bundle_0:2};
//   %wire_51 @TEXT("<*15>VSS", size=3.2, halign="middle", valign="top") => @PLACE(48, -173.7);
//   %wire_50 @TEXT("<*15>VSS", size=3.2, halign="middle", valign="top") => @PLACE(83.2, -173.7);
//   %wire_49 @TEXT("<*15>VSS", size=3.2, halign="middle", valign="top") => @PLACE(118.4, -173.7);
//   %p28 = (123.2, -86.4);
//   %wire_52 = &"VCM" @WIRE(mode="straight") {#"XFLASH":60 %p28};
//   %p29 = (123.2, -78.4);
//   %wire_53 = &"VCM" @WIRE(mode="straight") {#"XFLASH":75 %p29};
//   %wire_53 @TEXT("<*15>VCM", size=3.2, halign="start", valign="middle") => @PLACE(124.8, -78.4);
//   %wire_52 @TEXT("<*15>VCM", size=3.2, halign="start", valign="middle") => @PLACE(124.8, -86.4);
//   %wire_54 = {&"CODE_11" &"CODE_10" &"CODE_9" &"CODE_8" &"CODE_7" &"CODE_6" &"CODE_5" &"CODE_4" &"CODE_3" &"CODE_2" &"CODE_1" &"CODE_0"} @WIRE(mode="straight") {#"XMERGE":31 %port_4:1};
//   %wire_55 = &"TRACK" @WIRE(mode="straight") {#"XCLK":1 %port_5:p};
//   %p30 = (218.4, -24);
//   %wire_56 = &"TRACK" @WIRE(mode="straight") {%p30 #"XRA":7};
//   %wire_56 @TEXT("TRACK", size=3.2, halign="end", valign="middle") => @PLACE(216.8, -24);
//   %wire_57 = &"OVERFLOW" @WIRE(mode="straight") {#"XMERGE":45 %port_0:p};
//   %wire_58 = &"CHANNEL" @WIRE(mode="straight") {#"XMERGE":44 %port_1:p};
//   %wire_59 = &"RECON" @WIRE(mode="straight") {#"XMERGE":46 %port_3:p};
//   %wire_60 = {&"BIN_3" &"BIN_2" &"BIN_1" &"BIN_0"} @WIRE(mode="straight") {%bundle_3:1 %port_9:1};
//   %p31 = (123.2, -51.2);
//   %wire_61 = {&"BIN_3" &"BIN_2" &"BIN_1" &"BIN_0"} @WIRE(mode="straight") {#"XFLASH":1 %p31};
//   %wire_61 @TEXT("BIN<3:0>", size=3.2, halign="start", valign="middle") => @PLACE(124.8, -51.2);
//   %wire_62 = {&"D_14" &"D_13" &"D_12" &"D_11" &"D_10" &"D_9" &"D_8" &"D_7" &"D_6" &"D_5" &"D_4" &"D_3" &"D_2" &"D_1" &"D_0"} @WIRE(mode="straight") {#"XFLASH":5 #"XDAC":1};
//   %wire_63 = {&"D_14" &"D_13" &"D_12" &"D_11" &"D_10" &"D_9" &"D_8" &"D_7" &"D_6" &"D_5" &"D_4" &"D_3" &"D_2" &"D_1" &"D_0"} @WIRE(mode="straight") {%bundle_0:1 %port_10:1};
//   %wire_62 @TEXT("D<14:0>", size=3.5, halign="middle", valign="baseline") => @PLACE(131.2, 0.9);
//   %p32 = (320, 35.2);
//   %wire_64 = &"RON" @WIRE(mode="straight") {#"XRA":5 %p32};
//   %wire_65 = &"RON" @WIRE(mode="straight") {%p32 #"S_AN":1};
//   %p33 = (320, -80);
//   %wire_66 = &"RON" @WIRE(mode="straight") {%p33 %p32};
//   %wire_67 = &"RON" @WIRE(mode="straight") {%p33 #"S_BN":1};
//   %wire_68 = &"RON" @WIRE(mode="straight") {%p32 %port_18:p};
//   %wire_64 @TEXT("RON", size=3.5, halign="middle", valign="baseline") => @PLACE(315.2, 36.1);
//   %p34 = (310.4, 48);
//   %wire_69 = &"ROP" @WIRE(mode="straight") {#"XRA":6 %p34};
//   %wire_70 = &"ROP" @WIRE(mode="straight") {%p34 #"S_AP":1};
//   %p35 = (310.4, -67.2);
//   %wire_71 = &"ROP" @WIRE(mode="straight") {%p35 %p34};
//   %wire_72 = &"ROP" @WIRE(mode="straight") {%p35 #"S_BP":1};
//   %wire_73 = &"ROP" @WIRE(mode="straight") {%p34 %port_19:p};
//   %wire_70 @TEXT("ROP", size=3.5, halign="middle", valign="baseline") => @PLACE(315.2, 48.9);
//   %wire_74 = {&"KA_3" &"KA_2" &"KA_1" &"KA_0"} @WIRE(mode="straight") {#"XSARA":7 #"XMERGE":19};
//   %wire_74 @TEXT("KA<3:0>", size=3.5, halign="middle", valign="baseline") => @PLACE(501.6, 40.9);
//   %p36 = (218.4, -40);
//   %wire_75 = &"RESET" @WIRE(mode="straight") {%p36 #"XRA":4};
//   %p37 = (288.8, -160);
//   %wire_76 = &"RESET" @WIRE(mode="straight") {#"XCLK":3 %p37};
//   %wire_76 @TEXT("RESET", size=3.2, halign="start", valign="middle") => @PLACE(290.4, -160);
//   %wire_75 @TEXT("RESET", size=3.2, halign="end", valign="middle") => @PLACE(216.8, -40);
//   %wire_77 = &"OFB" @WIRE(mode="straight") {#"XSARB":11 #"XMERGE":30};
//   %wire_77 @TEXT("OFB", size=3.5, halign="middle", valign="baseline") => @PLACE(501.6, -90.3);
//   %wire_78 = &"OFA" @WIRE(mode="straight") {#"XSARA":11 #"XMERGE":29};
//   %wire_78 @TEXT("OFA", size=3.5, halign="middle", valign="baseline") => @PLACE(501.6, 24.9);
//   %wire_79 = &"DACP" @WIRE(mode="straight") {#"XDAC":16 #"XRA":3};
//   %wire_79 @TEXT("DACP", size=3.5, halign="middle", valign="baseline") => @PLACE(212.8, 0.9);
//   %wire_80 = &"DACN" @WIRE(mode="straight") {#"XDAC":17 #"XRA":2};
//   %wire_80 @TEXT("DACN", size=3.5, halign="middle", valign="baseline") => @PLACE(212.8, -11.9);
//   %wire_81 = {&"KB_3" &"KB_2" &"KB_1" &"KB_0"} @WIRE(mode="straight") {#"XSARB":7 #"XMERGE":23};
//   %wire_81 @TEXT("KB<3:0>", size=3.5, halign="middle", valign="baseline") => @PLACE(501.6, -74.3);
//   %wire_82 = &"IB_B" @WIRE(mode="straight") {#"XFLASH":51 %port_11:p};
//   %wire_83 = &"IB_A" @WIRE(mode="straight") {#"XFLASH":50 %port_12:p};
//   %wire_84 = &"VREFN" @WIRE(mode="straight") {%port_13:p #"XFLASH":90};
//   %p38 = (140, -16);
//   %wire_85 = &"VREFN" @WIRE(mode="straight") {%p38 #"XDAC":24};
//   %p39 = (389.6, -121.6);
//   %wire_86 = &"VREFN" @WIRE(mode="straight") {%p39 #"XSARB":29};
//   %p40 = (389.6, -6.4);
//   %wire_87 = &"VREFN" @WIRE(mode="straight") {%p40 #"XSARA":29};
//   %wire_87 @TEXT("VREFN", size=3.2, halign="end", valign="middle") => @PLACE(388, -6.4);
//   %wire_86 @TEXT("VREFN", size=3.2, halign="end", valign="middle") => @PLACE(388, -121.6);
//   %wire_85 @TEXT("VREFN", size=3.2, halign="end", valign="middle") => @PLACE(138.4, -16);
//   %wire_88 = &"VREFP" @WIRE(mode="straight") {%port_14:p #"XFLASH":91};
//   %p41 = (140, -8);
//   %wire_89 = &"VREFP" @WIRE(mode="straight") {%p41 #"XDAC":23};
//   %p42 = (389.6, -113.6);
//   %wire_90 = &"VREFP" @WIRE(mode="straight") {%p42 #"XSARB":30};
//   %p43 = (389.6, 1.6);
//   %wire_91 = &"VREFP" @WIRE(mode="straight") {%p43 #"XSARA":30};
//   %wire_91 @TEXT("VREFP", size=3.2, halign="end", valign="middle") => @PLACE(388, 1.6);
//   %wire_89 @TEXT("VREFP", size=3.2, halign="end", valign="middle") => @PLACE(138.4, -8);
//   %wire_90 @TEXT("VREFP", size=3.2, halign="end", valign="middle") => @PLACE(388, -113.6);
//   %wire_92 = &"VCM" @WIRE(mode="straight") {%port_15:p #"XFLASH":56};
//   %p44 = (140, -24);
//   %wire_93 = &"VCM" @WIRE(mode="straight") {%p44 #"XDAC":22};
//   %p45 = (304.8, -12.8);
//   %wire_94 = &"VCM" @WIRE(mode="straight") {#"XRA":8 %p45};
//   %p46 = (389.6, -129.6);
//   %wire_95 = &"VCM" @WIRE(mode="straight") {%p46 #"XSARB":23};
//   %p47 = (389.6, -14.4);
//   %wire_96 = &"VCM" @WIRE(mode="straight") {%p47 #"XSARA":23};
//   %p48 = (368, -92.4);
//   %wire_97 = &"VCM" @WIRE(mode="straight") {%p48 #"CH_BN":2};
//   %p49 = (368, -54.8);
//   %wire_98 = &"VCM" @WIRE(mode="straight") {#"CH_BP":2 %p49};
//   %p50 = (368, 22.8);
//   %wire_99 = &"VCM" @WIRE(mode="straight") {%p50 #"CH_AN":2};
//   %p51 = (368, 60.4);
//   %wire_100 = &"VCM" @WIRE(mode="straight") {#"CH_AP":2 %p51};
//   %wire_100 @TEXT("VCM", size=3.2, halign="middle", valign="baseline") => @PLACE(368, 61.7);
//   %wire_99 @TEXT("VCM", size=3.2, halign="middle", valign="top") => @PLACE(368, 21.5);
//   %wire_98 @TEXT("VCM", size=3.2, halign="middle", valign="baseline") => @PLACE(368, -53.5);
//   %wire_97 @TEXT("VCM", size=3.2, halign="middle", valign="top") => @PLACE(368, -93.7);
//   %wire_96 @TEXT("VCM", size=3.2, halign="end", valign="middle") => @PLACE(388, -14.4);
//   %wire_95 @TEXT("VCM", size=3.2, halign="end", valign="middle") => @PLACE(388, -129.6);
//   %wire_94 @TEXT("VCM", size=3.2, halign="start", valign="middle") => @PLACE(306.4, -12.8);
//   %wire_93 @TEXT("VCM", size=3.2, halign="end", valign="middle") => @PLACE(138.4, -24);
//   %wire_101 = &"VSS" @WIRE(mode="straight") {%port_16:p #"XFLASH":92};
//   %p52 = (140, -40);
//   %wire_102 = &"VSS" @WIRE(mode="straight") {%p52 #"XDAC":26};
//   %p53 = (304.8, -28.8);
//   %wire_103 = &"VSS" @WIRE(mode="straight") {#"XRA":12 %p53};
//   %p54 = (197.6, -120);
//   %wire_104 = &"VSS" @WIRE(mode="straight") {%p54 #"XCLK":11};
//   %p55 = (389.6, -145.6);
//   %wire_105 = &"VSS" @WIRE(mode="straight") {%p55 #"XSARB":31};
//   %p56 = (389.6, -30.4);
//   %wire_106 = &"VSS" @WIRE(mode="straight") {%p56 #"XSARA":31};
//   %p57 = (500.4, -107.2);
//   %wire_107 = &"VSS" @WIRE(mode="straight") {#"CPROBE7":2 %p57};
//   %p58 = (500.4, 8);
//   %wire_108 = &"VSS" @WIRE(mode="straight") {#"CPROBE6":2 %p58};
//   %p59 = (500.4, -131.2);
//   %wire_109 = &"VSS" @WIRE(mode="straight") {#"CPROBE5":2 %p59};
//   %p60 = (500.4, -16);
//   %wire_110 = &"VSS" @WIRE(mode="straight") {#"CPROBE4":2 %p60};
//   %p61 = (500.4, -115.2);
//   %wire_111 = &"VSS" @WIRE(mode="straight") {#"CPROBE3":2 %p61};
//   %p62 = (500.4, 0);
//   %wire_112 = &"VSS" @WIRE(mode="straight") {#"CPROBE2":2 %p62};
//   %p63 = (500.4, -123.2);
//   %wire_113 = &"VSS" @WIRE(mode="straight") {#"CPROBE1":2 %p63};
//   %p64 = (500.4, -8);
//   %wire_114 = &"VSS" @WIRE(mode="straight") {#"CPROBE0":2 %p64};
//   %p65 = (612, -112);
//   %wire_115 = &"VSS" @WIRE(mode="straight") {#"XMERGE":48 %p65};
//   %wire_115 @TEXT("VSS", size=3.2, halign="start", valign="middle") => @PLACE(613.6, -112);
//   %wire_114 @TEXT("VSS", size=3.2, halign="start", valign="middle") => @PLACE(502, -8);
//   %wire_113 @TEXT("VSS", size=3.2, halign="start", valign="middle") => @PLACE(502, -123.2);
//   %wire_112 @TEXT("VSS", size=3.2, halign="start", valign="middle") => @PLACE(502, 0);
//   %wire_111 @TEXT("VSS", size=3.2, halign="start", valign="middle") => @PLACE(502, -115.2);
//   %wire_110 @TEXT("VSS", size=3.2, halign="start", valign="middle") => @PLACE(502, -16);
//   %wire_109 @TEXT("VSS", size=3.2, halign="start", valign="middle") => @PLACE(502, -131.2);
//   %wire_108 @TEXT("VSS", size=3.2, halign="start", valign="middle") => @PLACE(502, 8);
//   %wire_107 @TEXT("VSS", size=3.2, halign="start", valign="middle") => @PLACE(502, -107.2);
//   %wire_106 @TEXT("VSS", size=3.2, halign="end", valign="middle") => @PLACE(388, -30.4);
//   %wire_105 @TEXT("VSS", size=3.2, halign="end", valign="middle") => @PLACE(388, -145.6);
//   %wire_104 @TEXT("VSS", size=3.2, halign="end", valign="middle") => @PLACE(196, -120);
//   %wire_103 @TEXT("VSS", size=3.2, halign="start", valign="middle") => @PLACE(306.4, -28.8);
//   %wire_102 @TEXT("VSS", size=3.2, halign="end", valign="middle") => @PLACE(138.4, -40);
//   %wire_116 = &"VDD" @WIRE(mode="straight") {%port_17:p #"XFLASH":57};
//   %p66 = (140, -32);
//   %wire_117 = &"VDD" @WIRE(mode="straight") {%p66 #"XDAC":25};
//   %p67 = (304.8, -20.8);
//   %wire_118 = &"VDD" @WIRE(mode="straight") {#"XRA":9 %p67};
//   %p68 = (197.6, -112);
//   %wire_119 = &"VDD" @WIRE(mode="straight") {%p68 #"XCLK":10};
//   %p69 = (389.6, -137.6);
//   %wire_120 = &"VDD" @WIRE(mode="straight") {%p69 #"XSARB":25};
//   %p70 = (389.6, -22.4);
//   %wire_121 = &"VDD" @WIRE(mode="straight") {%p70 #"XSARA":25};
//   %p71 = (612, -104);
//   %wire_122 = &"VDD" @WIRE(mode="straight") {#"XMERGE":47 %p71};
//   %wire_122 @TEXT("VDD", size=3.2, halign="start", valign="middle") => @PLACE(613.6, -104);
//   %wire_121 @TEXT("VDD", size=3.2, halign="end", valign="middle") => @PLACE(388, -22.4);
//   %wire_120 @TEXT("VDD", size=3.2, halign="end", valign="middle") => @PLACE(388, -137.6);
//   %wire_119 @TEXT("VDD", size=3.2, halign="end", valign="middle") => @PLACE(196, -112);
//   %wire_118 @TEXT("VDD", size=3.2, halign="start", valign="middle") => @PLACE(306.4, -20.8);
//   %wire_117 @TEXT("VDD", size=3.2, halign="end", valign="middle") => @PLACE(138.4, -32);
//   %p72 = (24, 35.2);
//   %wire_123 = &"VINN" @WIRE(mode="straight") {%port_22:p %p72};
//   %wire_124 = &"VINN" @WIRE(mode="straight") {%p72 #"XRA":10};
//   %p73 = (24, -12.8);
//   %wire_125 = &"VINN" @WIRE(mode="straight") {%p73 %p72};
//   %wire_126 = &"VINN" @WIRE(mode="straight") {%p73 #"XFLASH":58};
//   %p74 = (16, 48);
//   %wire_127 = &"VINP" @WIRE(mode="straight") {%port_23:p %p74};
//   %wire_128 = &"VINP" @WIRE(mode="straight") {%p74 #"XRA":11};
//   %p75 = (16, 0);
//   %wire_129 = &"VINP" @WIRE(mode="straight") {%p75 %p74};
//   %wire_130 = &"VINP" @WIRE(mode="straight") {%p75 #"XFLASH":59};
//   $JUNCTION @ATTACH %p32;
//   $JUNCTION @ATTACH %p34;
//   $JUNCTION @ATTACH %p72;
//   $JUNCTION @ATTACH %p74;
//   (-8, 92.8) @TEXT("VDD = 1 V    VCM = 0.5 V    quantizer FS = 2 Vpp differential    input = Ain", size=4.5, halign="start", valign="baseline");
//   (-8, 107.2) @TEXT("PIPE-TI-SAR  |  1 GS/s  |  4b Flash + G8 residue + 2 x real 9b SAR", size=7, halign="start", valign="baseline");
//   (629.6, -14.4) @TEXT("OVERFLOW", size=3.5, halign="start", valign="baseline");
//   (629.6, 1.6) @TEXT("CHANNEL", size=3.5, halign="start", valign="baseline");
//   (629.6, 17.6) @TEXT("VALID", size=3.5, halign="start", valign="baseline");
//   (629.6, 33.6) @TEXT("RECON", size=3.5, halign="start", valign="baseline");
//   (629.6, 49.6) @TEXT("CODE<11:0>", size=3.5, halign="start", valign="baseline");
//   (306.4, -174.4) @TEXT("TB", size=3.5, halign="start", valign="baseline");
//   (306.4, -166.4) @TEXT("TA", size=3.5, halign="start", valign="baseline");
//   (306.4, -150.4) @TEXT("AMP", size=3.5, halign="start", valign="baseline");
//   (306.4, -110.4) @TEXT("TRACK", size=3.5, halign="start", valign="baseline");
//   (156, -145.6) @TEXT("BIN<3:0>", size=3.5, halign="start", valign="baseline");
//   (50.4, -145.6) @TEXT("D<14:0>", size=3.5, halign="start", valign="baseline");
//   (157.6, -105.6) @TEXT("IB\_B", size=3.5, halign="end", valign="baseline");
//   (360, -207.2) @TEXT("AMP", size=4, halign="start", valign="baseline");
//   (360, -196.8) @TEXT("FLASH", size=4, halign="start", valign="baseline");
//   (157.6, -96) @TEXT("IB\_A", size=3.5, halign="end", valign="baseline");
//   (360, -186.4) @TEXT("TRACK", size=4, halign="start", valign="baseline");
//   (368, -168) @TEXT("Timing within one 1 ns front-end period", size=4.8, halign="start", valign="baseline");
//   (5.6, -89.6) @TEXT("VREFN", size=3.5, halign="end", valign="baseline");
//   (208, -201.6) @TEXT("TA / TB alternate every 1 ns", size=4.2, halign="start", valign="baseline");
//   (48, -201.6) @TEXT("K<3:0> = coarse code sent to both SAR lanes", size=3.8, halign="start", valign="baseline");
//   (5.6, -81.6) @TEXT("VREFP", size=3.5, halign="end", valign="baseline");
//   (48, -192) @TEXT("D = thermometer code; BIN = binary monitor", size=3.8, halign="start", valign="baseline");
//   (48, -136) @TEXT("Flash output loads  /  Cflash", size=4.3, halign="start", valign="baseline");
//   (5.6, -97.6) @TEXT("VCM", size=3.5, halign="end", valign="baseline");
//   (336, -36.8) @TEXT("S/H B: Cs2 per side", size=3.7, halign="start", valign="baseline");
//   (5.6, -113.6) @TEXT("VSS", size=3.5, halign="end", valign="baseline");
//   (336, 78.4) @TEXT("S/H A: Cs2 per side", size=3.7, halign="start", valign="baseline");
//   (5.6, -105.6) @TEXT("VDD", size=3.5, halign="end", valign="baseline");
//   (400, -50.4) @TEXT("Lane B  /  500 MS/s", size=4.6, halign="start", valign="baseline");
//   (400, 70.4) @TEXT("Lane A  /  500 MS/s", size=4.6, halign="start", valign="baseline");
//   (322.4, 65.6) @TEXT("RON", size=3.5, halign="start", valign="baseline");
//   (312.8, 73.6) @TEXT("ROP", size=3.5, halign="start", valign="baseline");
//   (511.2, -81.6) @TEXT("DB", size=3.5, halign="start", valign="baseline");
//   (448, -178.4) @TEXT("250 ps", size=3.7, halign="start", valign="baseline");
//   (511.2, 33.6) @TEXT("DA", size=3.5, halign="start", valign="baseline");
//   (496, -178.4) @TEXT("500 ps", size=3.7, halign="start", valign="baseline");
//   (592, -178.4) @TEXT("1 ns", size=3.7, halign="start", valign="baseline");
//   (368, -230.4) @TEXT("* TB uses the next period; conversion continues after track closes.", size=4, halign="start", valign="baseline");
//   (-10.4, 36.8) @TEXT("VINN", size=3.5, halign="end", valign="baseline");
//   (48, -211.2) @TEXT("ROP/RON: residue    DA/DB: lane done    VALID: output strobe", size=3.8, halign="start", valign="baseline");
//   (-10.4, 49.6) @TEXT("VINP", size=3.5, halign="end", valign="baseline");
//   (224, 75.2) @TEXT("Ideal OTA inside", size=4, halign="start", valign="baseline");
//   (400, -178.4) @TEXT("0", size=3.7, halign="start", valign="baseline");
//   (360, -217.6) @TEXT("TA*", size=4, halign="start", valign="baseline");
//   @LINE {(400, -217.6) (496, -217.6) (496, -213.6) (590.1, -213.6) (590.1, -217.6) (592, -217.6)};
//   @LINE {(400, -196.8) (448, -196.8) (448, -192.8) (496, -192.8) (496, -196.8) (592, -196.8)};
//   @LINE {(400, -207.2) (496, -207.2) (496, -203.2) (592, -203.2) (592, -207.2) (592, -207.2)};
//   @LINE {(400, -186.4) (400, -186.4) (400, -182.4) (448, -182.4) (448, -186.4) (592, -186.4)}
// }
ends PIPE_TOP_F4_RS9_N06
