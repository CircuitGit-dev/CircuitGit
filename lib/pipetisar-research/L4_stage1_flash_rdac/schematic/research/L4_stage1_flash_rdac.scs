// @RNL(type="header") {
// @VERSION("0.3");
// @USE-PACKAGE(name="rnl-std-spectre", version="0.3", path="rnl-std-spectre.rnl");
// @USE-PACKAGE(name="eda-symbol", version="0.1", path="eda-symbol.rnl");
// @USE-PACKAGE(name="eda-style", version="0.1", path="eda-style.rnl")
// }
// Design: 2026_PIPETISAR_RESEARCH/L4_stage1_flash_rdac
simulator lang=spectre
global 0

// 2026_PIPETISAR_RESEARCH/L4_stage1_flash_rdac/schematic
subckt L4_stage1_flash_rdac VOSREF_2 VOSREF_1 VOSREF_0 VREF_7 VREF_6 VREF_5 VREF_4 VREF_3 VREF_2 VREF_1 VREF_0 VREFN VREFP
R15 (net1 VREF_0 ) rnods l=1.5u w=1u m=1 multi=(1)

R13 (net2 VREF_1 ) rnods l=1.5u w=1u m=1 multi=(1)

R12 (VREF_2 net2 ) rnods l=1.5u w=1u m=1 multi=(1)

R10 (VREF_3 VOSREF_0 ) rnods l=1.5u w=1u m=1 multi=(1)

R8 (VREF_4 VOSREF_1 ) rnods l=1.5u w=1u m=1 multi=(1)

R9 (VOSREF_1 VREF_3 ) rnods l=1.5u w=1u m=1 multi=(1)

R11 (VOSREF_0 VREF_2 ) rnods l=1.5u w=1u m=1 multi=(1)

//Series configuration of R0
R0 (VREFP R0_1__dmy0 ) rnods l=1.5u w=1u m=1 multi=(1)
R0_2__dmy0 (R0_1__dmy0 R0_2__dmy0 ) rnods l=1.5u w=1u m=1 multi=(1)
R0_3__dmy0 (R0_2__dmy0 R0_3__dmy0 ) rnods l=1.5u w=1u m=1 multi=(1)
R0_4__dmy0 (R0_3__dmy0 R0_4__dmy0 ) rnods l=1.5u w=1u m=1 multi=(1)
R0_5__dmy0 (R0_4__dmy0 R0_5__dmy0 ) rnods l=1.5u w=1u m=1 multi=(1)
R0_6__dmy0 (R0_5__dmy0 R0_6__dmy0 ) rnods l=1.5u w=1u m=1 multi=(1)
R0_7__dmy0 (R0_6__dmy0 R0_7__dmy0 ) rnods l=1.5u w=1u m=1 multi=(1)
R0_8__dmy0 (R0_7__dmy0 R0_8__dmy0 ) rnods l=1.5u w=1u m=1 multi=(1)
R0_9__dmy0 (R0_8__dmy0 VREF_7 ) rnods l=1.5u w=1u m=1 multi=(1)
//End of R0

//Series configuration of R1
R1 (VREFN R1_1__dmy0 ) rnods l=1.5u w=1u m=1 multi=(1)
R1_2__dmy0 (R1_1__dmy0 R1_2__dmy0 ) rnods l=1.5u w=1u m=1 multi=(1)
R1_3__dmy0 (R1_2__dmy0 R1_3__dmy0 ) rnods l=1.5u w=1u m=1 multi=(1)
R1_4__dmy0 (R1_3__dmy0 R1_4__dmy0 ) rnods l=1.5u w=1u m=1 multi=(1)
R1_5__dmy0 (R1_4__dmy0 R1_5__dmy0 ) rnods l=1.5u w=1u m=1 multi=(1)
R1_6__dmy0 (R1_5__dmy0 R1_6__dmy0 ) rnods l=1.5u w=1u m=1 multi=(1)
R1_7__dmy0 (R1_6__dmy0 R1_7__dmy0 ) rnods l=1.5u w=1u m=1 multi=(1)
R1_8__dmy0 (R1_7__dmy0 R1_8__dmy0 ) rnods l=1.5u w=1u m=1 multi=(1)
R1_9__dmy0 (R1_8__dmy0 VREF_0 ) rnods l=1.5u w=1u m=1 multi=(1)
//End of R1

R3 (net4 VREF_6 ) rnods l=1.5u w=1u m=1 multi=(1)

R6 (VREF_5 VOSREF_2 ) rnods l=1.5u w=1u m=1 multi=(1)

R4 (VREF_6 net3 ) rnods l=1.5u w=1u m=1 multi=(1)

R2 (VREF_7 net4 ) rnods l=1.5u w=1u m=1 multi=(1)

R5 (net3 VREF_5 ) rnods l=1.5u w=1u m=1 multi=(1)

R7 (VOSREF_2 VREF_4 ) rnods l=1.5u w=1u m=1 multi=(1)

R14 (VREF_1 net1 ) rnods l=1.5u w=1u m=1 multi=(1)

// @RNL(author="rnl-virtuoso") {
// %block_symbol = @DEFINE-SYMBOL(box=[-6, -10, 14, 10]) {
// @LINE {(16, -4) (12, -4)};
// @LINE {(-8, 1) (-4, 1)};
// @LINE {(-8, -1) (-4, -1)};
// @LINE {(4, -5) (4, -6) (2, -6)};
// @LINE {(4, 6) (4, 6) (2, 6)};
// @LINE {(4, -6) (4, -4.8) (3, -4.5) (5, -3.9) (3, -3.3) (5, -2.7) (3, -2.1) (5, -1.5) (4, -1.2) (4, 0)};
// @LINE {(4, 0) (4, 1.2) (3, 1.5) (5, 2.1) (3, 2.7) (5, 3.3) (3, 3.9) (5, 4.5) (4, 4.8) (4, 6)};
// @LINE {(4, 0) (7, 0)};
// @RECTANGLE {(-4, -8) (12, 8)};
// @LINE {(16, 0) (12, 0)};
// ? @TEXT("${name}", size=1, halign="start", valign="middle", key="name") => @PLACE(10, 9);
// ? @TEXT("${model}", size=1, halign="start", valign="middle", key="model") => @PLACE(10, 7);
// (16, -4) @PIN(terminal=["VOSREF_2", "VOSREF_1", "VOSREF_0"]);
// (11.4, -4) @TEXT("VOSREF<2:0>", size=1, halign="end", valign="middle");
// (-8, -1) @PIN(terminal="VREFN");
// (-3.4, -1) @TEXT("VREFN", size=1, halign="start", valign="middle");
// (-8, 1) @PIN(terminal="VREFP");
// (-3.4, 1) @TEXT("VREFP", size=1, halign="start", valign="middle");
// (16, 0) @PIN(terminal=["VREF_7", "VREF_6", "VREF_5", "VREF_4", "VREF_3", "VREF_2", "VREF_1", "VREF_0"]);
// (11.4, 0) @TEXT("VREF<7:0>", size=1, halign="end", valign="middle")
// };
// # @SET-SYMBOL %block_symbol;
// %symbol_0 = @DEFINE-SYMBOL(box=[-2, -6, 2, 0]) {
// @LINE {(0, -6) (0, -4.8) (-1, -4.5) (1, -3.9) (-1, -3.3) (1, -2.7) (-1, -2.1) (1, -1.5) (0, -1.2) (0, 0)};
// ? @TEXT("${name}", size=0.8, halign="start", valign="baseline", key="name") => @PLACE(1.4, 0.5);
// ? @TEXT("${model}", size=0.8, halign="end", valign="baseline", key="model") => @PLACE(-1, 0.3);
// (0, -6) @PIN(terminal=2);
// (0, 0) @PIN(terminal=1)
// };
// #"R10" @SET-SYMBOL %symbol_0;
// #"R10" @PLACE(56, -33) => @ORIENT("R0");
// #"R15" @SET-SYMBOL %symbol_0;
// #"R15" @PLACE(56, -73) => @ORIENT("R0");
// #"R6" @SET-SYMBOL %symbol_0;
// #"R6" @PLACE(56, -1) => @ORIENT("R0");
// #"R13" @SET-SYMBOL %symbol_0;
// #"R13" @PLACE(56, -57) => @ORIENT("R0");
// #"R8" @SET-SYMBOL %symbol_0;
// #"R8" @PLACE(56, -17) => @ORIENT("R0");
// #"R9" @SET-SYMBOL %symbol_0;
// #"R9" @PLACE(56, -25) => @ORIENT("R0");
// #"R4" @SET-SYMBOL %symbol_0;
// #"R4" @PLACE(56, 15) => @ORIENT("R0");
// #"R11" @SET-SYMBOL %symbol_0;
// #"R11" @PLACE(56, -41) => @ORIENT("R0");
// #"R14" @SET-SYMBOL %symbol_0;
// #"R14" @PLACE(56, -65) => @ORIENT("R0");
// #"R2" @SET-SYMBOL %symbol_0;
// #"R2" @PLACE(56, 31) => @ORIENT("R0");
// #"R7" @SET-SYMBOL %symbol_0;
// #"R7" @PLACE(56, -9) => @ORIENT("R0");
// #"R5" @SET-SYMBOL %symbol_0;
// #"R5" @PLACE(56, 7) => @ORIENT("R0");
// %expanded_type_2 = @DEFINE(roles=["{parts}", ["p1", "terminal"], ["p2", "terminal"]]) {};
// %expanded_members_symbol = @DEFINE-SYMBOL {};
// {#"R0" #"R0_2__dmy0" #"R0_3__dmy0" #"R0_4__dmy0" #"R0_5__dmy0" #"R0_6__dmy0" #"R0_7__dmy0" #"R0_8__dmy0" #"R0_9__dmy0"} @SET-SYMBOL %expanded_members_symbol;
// {#"R0" #"R0_2__dmy0" #"R0_3__dmy0" #"R0_4__dmy0" #"R0_5__dmy0" #"R0_6__dmy0" #"R0_7__dmy0" #"R0_8__dmy0" #"R0_9__dmy0"} @PLACE(45, 33);
// %expanded_0 = {#"R0" #"R0_2__dmy0" #"R0_3__dmy0" #"R0_4__dmy0" #"R0_5__dmy0" #"R0_6__dmy0" #"R0_7__dmy0" #"R0_8__dmy0" #"R0_9__dmy0"}(parts) #"R0":1(p1) #"R0_9__dmy0":2(p2) @AS %expanded_type_2;
// %symbol_1 = @DEFINE-SYMBOL(box=[-2, -6, 2, 0]) {
// @LINE {(0, -6) (0, -4.8) (-1, -4.5) (1, -3.9) (-1, -3.3) (1, -2.7) (-1, -2.1) (1, -1.5) (0, -1.2) (0, 0)};
// ? @TEXT("${name}", size=0.8, halign="start", valign="baseline", key="name") => @PLACE(1.4, 0.5);
// ? @TEXT("${model}", size=0.8, halign="end", valign="baseline", key="model") => @PLACE(-1, 0.3);
// (0, -6) @PIN(terminal="p2");
// (0, 0) @PIN(terminal="p1")
// };
// %expanded_0 @SET-SYMBOL %symbol_1;
// %expanded_0 @PLACE(45, 33) => @ORIENT("R90");
// %expanded_0 @TEXT("R0", key="name");
// %expanded_0 @TEXT("rnods", key="model");
// {#"R1" #"R1_2__dmy0" #"R1_3__dmy0" #"R1_4__dmy0" #"R1_5__dmy0" #"R1_6__dmy0" #"R1_7__dmy0" #"R1_8__dmy0" #"R1_9__dmy0"} @SET-SYMBOL %expanded_members_symbol;
// {#"R1" #"R1_2__dmy0" #"R1_3__dmy0" #"R1_4__dmy0" #"R1_5__dmy0" #"R1_6__dmy0" #"R1_7__dmy0" #"R1_8__dmy0" #"R1_9__dmy0"} @PLACE(45, -81);
// %expanded_1 = {#"R1" #"R1_2__dmy0" #"R1_3__dmy0" #"R1_4__dmy0" #"R1_5__dmy0" #"R1_6__dmy0" #"R1_7__dmy0" #"R1_8__dmy0" #"R1_9__dmy0"}(parts) #"R1":1(p1) #"R1_9__dmy0":2(p2) @AS %expanded_type_2;
// %expanded_1 @SET-SYMBOL %symbol_1;
// %expanded_1 @PLACE(45, -81) => @ORIENT("R90");
// %expanded_1 @TEXT("R1", key="name");
// %expanded_1 @TEXT("rnods", key="model");
// #"R3" @SET-SYMBOL %symbol_0;
// #"R3" @PLACE(56, 23) => @ORIENT("R0");
// #"R12" @SET-SYMBOL %symbol_0;
// #"R12" @PLACE(56, -49) => @ORIENT("R0");
// %port_0 = $IO_PORT @ATTACH &"VREFP" => @PLACE(20, 36) => @ORIENT("R0");
// %port_1 = $IO_PORT @ATTACH &"VREFN" => @PLACE(20, 32) => @ORIENT("R0");
// %output_port_symbol = @DEFINE-SYMBOL(box=[0, -1, 2, 1]) {
// @LINE(fill="linecolor", linestyle="none") {(0, -0.9) (0, 0.9) (1.1, 0.9) (2, 0) (1.1, -0.9) (0, -0.9)};
// (0, 0) @PIN(terminal=1, direction="left");
// ? @TEXT("${name}", key="name", halign="middle") => @PLACE(1, 1.6)
// };
// %bus_port_type_2 = @DEFINE(roles=[["p", "net"], ["p1", "net"], ["p2", "net"]]) {};
// %bus_port_type_2_symbol = @DEFINE-SYMBOL {(0, 0) @PIN(terminal=[1, 2, 3])};
// {&"VOSREF_2" &"VOSREF_1" &"VOSREF_0"} @REMOVE-FROM $PORT_FILL_SET;
// %port_2 = %bus_port_type_2 @ATTACH &"VOSREF_2" &"VOSREF_1" &"VOSREF_0" => @PLACE(19, 24) => @ORIENT("R0");
// %port_2 @SET-SYMBOL %bus_port_type_2_symbol;
// %port_2_marker = $IO_PORT @ATTACH &"VOSREF_2" => @PLACE(19, 24) => @ORIENT("R0");
// %port_2_marker @SET-SYMBOL %output_port_symbol;
// %port_2_marker @TEXT("VOSREF<2:0>", key="name");
// %bus_port_type_3 = @DEFINE(roles=[["p", "net"], ["p1", "net"], ["p2", "net"], ["p3", "net"], ["p4", "net"], ["p5", "net"], ["p6", "net"], ["p7", "net"]]) {};
// %bus_port_type_3_symbol = @DEFINE-SYMBOL {(0, 0) @PIN(terminal=[1, 2, 3, 4, 5, 6, 7, 8])};
// {&"VREF_7" &"VREF_6" &"VREF_5" &"VREF_4" &"VREF_3" &"VREF_2" &"VREF_1" &"VREF_0"} @REMOVE-FROM $PORT_FILL_SET;
// %port_3 = %bus_port_type_3 @ATTACH &"VREF_7" &"VREF_6" &"VREF_5" &"VREF_4" &"VREF_3" &"VREF_2" &"VREF_1" &"VREF_0" => @PLACE(19, 28) => @ORIENT("R0");
// %port_3 @SET-SYMBOL %bus_port_type_3_symbol;
// %port_3_marker = $IO_PORT @ATTACH &"VREF_7" => @PLACE(19, 28) => @ORIENT("R0");
// %port_3_marker @SET-SYMBOL %output_port_symbol;
// %port_3_marker @TEXT("VREF<7:0>", key="name");
// %p0 = (48, -40);
// %p1 = (56, -40);
// %wire_0 = &"VOSREF_0" @WIRE(mode="straight") {%p0 %p1};
// %wire_1 = &"VOSREF_0" @WIRE(mode="straight") {#"R11":1 %p1};
// %wire_2 = &"VOSREF_0" @WIRE(mode="straight") {%p1 #"R10":2};
// %wire_0 @TEXT("VOSREF\_0", size=1, halign="middle", valign="baseline") => @PLACE(48, -39.3);
// %p2 = (48, -24);
// %p3 = (56, -24);
// %wire_3 = &"VOSREF_1" @WIRE(mode="straight") {%p2 %p3};
// %wire_4 = &"VOSREF_1" @WIRE(mode="straight") {#"R9":1 %p3};
// %wire_5 = &"VOSREF_1" @WIRE(mode="straight") {%p3 #"R8":2};
// %wire_3 @TEXT("VOSREF\_1", size=1, halign="middle", valign="baseline") => @PLACE(48, -23.3);
// %p4 = (56, -8);
// %wire_6 = &"VOSREF_2" @WIRE(mode="straight") {%p4 #"R6":2};
// %p5 = (48, -8);
// %wire_7 = &"VOSREF_2" @WIRE(mode="straight") {%p5 %p4};
// %wire_8 = &"VOSREF_2" @WIRE(mode="straight") {#"R7":1 %p4};
// %wire_7 @TEXT("VOSREF\_2", size=1, halign="middle", valign="baseline") => @PLACE(49, -7.3);
// %wire_9 = &"net1" @WIRE(mode="straight") {#"R15":1 #"R14":2};
// %wire_10 = &"net2" @WIRE(mode="straight") {#"R13":1 #"R12":2};
// %wire_11 = &"net3" @WIRE(mode="straight") {#"R5":1 #"R4":2};
// %wire_12 = &"net4" @WIRE(mode="straight") {#"R3":1 #"R2":2};
// %p6 = (56, 33);
// %p7 = (80, 33);
// %wire_13 = &"VREF_7" @WIRE(mode="straight") {%p6 %p7};
// %wire_14 = &"VREF_7" @WIRE(mode="straight") {%expanded_0:p2 %p6};
// %wire_15 = &"VREF_7" @WIRE(mode="straight") {#"R2":1 %p6};
// %wire_13 @TEXT("VREF\_7", size=1, halign="middle", valign="baseline") => @PLACE(80, 33.7);
// %p8 = (56, 16);
// %wire_16 = &"VREF_6" @WIRE(mode="straight") {#"R4":1 %p8};
// %wire_17 = &"VREF_6" @WIRE(mode="straight") {%p8 #"R3":2};
// %p9 = (80, 16);
// %wire_18 = &"VREF_6" @WIRE(mode="straight") {%p8 %p9};
// %wire_18 @TEXT("VREF\_6", size=1, halign="middle", valign="baseline") => @PLACE(80, 16.7);
// %p10 = (56, 0);
// %p11 = (80, 0);
// %wire_19 = &"VREF_5" @WIRE(mode="straight") {%p10 %p11};
// %wire_20 = &"VREF_5" @WIRE(mode="straight") {#"R6":1 %p10};
// %wire_21 = &"VREF_5" @WIRE(mode="straight") {%p10 #"R5":2};
// %wire_19 @TEXT("VREF\_5", size=1, halign="middle", valign="baseline") => @PLACE(80, 0.7);
// %p12 = (56, -16);
// %p13 = (80, -16);
// %wire_22 = &"VREF_4" @WIRE(mode="straight") {%p12 %p13};
// %wire_23 = &"VREF_4" @WIRE(mode="straight") {%p12 #"R7":2};
// %wire_24 = &"VREF_4" @WIRE(mode="straight") {#"R8":1 %p12};
// %wire_22 @TEXT("VREF\_4", size=1, halign="middle", valign="baseline") => @PLACE(80, -15.3);
// %p14 = (56, -32);
// %p15 = (80, -32);
// %wire_25 = &"VREF_3" @WIRE(mode="straight") {%p14 %p15};
// %wire_26 = &"VREF_3" @WIRE(mode="straight") {#"R10":1 %p14};
// %wire_27 = &"VREF_3" @WIRE(mode="straight") {%p14 #"R9":2};
// %wire_25 @TEXT("VREF\_3", size=1, halign="middle", valign="baseline") => @PLACE(80, -31.3);
// %p16 = (56, -48);
// %wire_28 = &"VREF_2" @WIRE(mode="straight") {#"R12":1 %p16};
// %p17 = (80, -48);
// %wire_29 = &"VREF_2" @WIRE(mode="straight") {%p16 %p17};
// %wire_30 = &"VREF_2" @WIRE(mode="straight") {%p16 #"R11":2};
// %wire_29 @TEXT("VREF\_2", size=1, halign="middle", valign="baseline") => @PLACE(80, -47.3);
// %p18 = (56, -64);
// %wire_31 = &"VREF_1" @WIRE(mode="straight") {#"R14":1 %p18};
// %p19 = (80, -64);
// %wire_32 = &"VREF_1" @WIRE(mode="straight") {%p18 %p19};
// %wire_33 = &"VREF_1" @WIRE(mode="straight") {%p18 #"R13":2};
// %wire_32 @TEXT("VREF\_1", size=1, halign="middle", valign="baseline") => @PLACE(80, -63.3);
// %p20 = (56, -81);
// %wire_34 = &"VREF_0" @WIRE(mode="straight") {%expanded_1:p2 %p20};
// %p21 = (80, -81);
// %wire_35 = &"VREF_0" @WIRE(mode="straight") {%p20 %p21};
// %wire_36 = &"VREF_0" @WIRE(mode="straight") {%p20 #"R15":2};
// %wire_35 @TEXT("VREF\_0", size=1, halign="middle", valign="baseline") => @PLACE(80, -80.3);
// %p22 = (40, -81);
// %wire_37 = &"VREFN" @WIRE(mode="straight") {%p22 %expanded_1:p1};
// %wire_37 @TEXT("VREFN", size=1, halign="middle", valign="baseline") => @PLACE(42, -80.3);
// %p23 = (40, 33);
// %wire_38 = &"VREFP" @WIRE(mode="straight") {%p23 %expanded_0:p1};
// %wire_38 @TEXT("VREFP", size=1, halign="middle", valign="baseline") => @PLACE(42, 33.7);
// $JUNCTION @ATTACH %p1;
// $JUNCTION @ATTACH %p3;
// $JUNCTION @ATTACH %p4;
// $JUNCTION @ATTACH %p6;
// $JUNCTION @ATTACH %p8;
// $JUNCTION @ATTACH %p10;
// $JUNCTION @ATTACH %p12;
// $JUNCTION @ATTACH %p14;
// $JUNCTION @ATTACH %p16;
// $JUNCTION @ATTACH %p18;
// $JUNCTION @ATTACH %p20
// }
ends L4_stage1_flash_rdac
