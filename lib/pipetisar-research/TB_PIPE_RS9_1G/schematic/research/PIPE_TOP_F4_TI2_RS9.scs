// Generated for: spectre
// @RNL(type="header") {
//   @VERSION("0.3");
//   @USE-PACKAGE(name="rnl-std-spectre", version="0.3", path="rnl-std-spectre.rnl");
//   @USE-PACKAGE(name="eda-symbol", version="0.1", path="eda-symbol.rnl");
//   @USE-PACKAGE(name="eda-style", version="0.1", path="eda-style.rnl")
// }
// Generated on: Nov  9 19:41:09 2026
// Design library name: 2026_PIPETISAR_RESEARCH
// Design cell name: PIPE_TOP_F4_TI2_RS9
// Design view name: schematic
simulator lang=spectre
global 0

// Library name: 2026_PIPETISAR_RESEARCH
// Cell name: Switch
// View name: schematic
// End of subcircuit definition.

// Library name: 2026_PIPETISAR_RESEARCH
// Cell name: PIPE_OTA_Diff_Ideal
// View name: schematic
// End of subcircuit definition.

// Library name: 2026_PIPETISAR_RESEARCH
// Cell name: PIPE_MDAC4_G8_SC
// View name: schematic
// End of subcircuit definition.

// Library name: 2026_PIPETISAR_RESEARCH
// Cell name: RS9_L5_9bit_Bootstrap
// View name: schematic
// End of subcircuit definition.

// Library name: 2026_PIPETISAR_RESEARCH
// Cell name: RS9_L5_9bit_Comparator_LN
// View name: schematic
// End of subcircuit definition.

// Library name: 2026_PIPETISAR_RESEARCH
// Cell name: RS9_L6_SR_latch_1
// View name: schematic
// End of subcircuit definition.

// Library name: 2026_PIPETISAR_RESEARCH
// Cell name: RS9_L6_9bit_REF_Logic
// View name: schematic
// End of subcircuit definition.

// Library name: 2026_PIPETISAR_RESEARCH
// Cell name: RS9_L5_9bit_SAR_Logic_1
// View name: schematic
// End of subcircuit definition.

// Library name: 2026_PIPETISAR_RESEARCH
// Cell name: RS9_L8_9bit_CDAC_UNIT
// View name: schematic
// End of subcircuit definition.

// Library name: 2026_PIPETISAR_RESEARCH
// Cell name: RS9_L7_9bit_CDAC
// View name: schematic
// End of subcircuit definition.

// Library name: 2026_PIPETISAR_RESEARCH
// Cell name: RS9_L6_9bit_RSW
// View name: schematic
// End of subcircuit definition.

// Library name: 2026_PIPETISAR_RESEARCH
// Cell name: RS9_L5_9bit_RSW_CDAC
// View name: schematic
// End of subcircuit definition.

// Library name: 2026_PIPETISAR_RESEARCH
// Cell name: RS9_L3_9bit_SAR_2
// View name: schematic
// End of subcircuit definition.

// Library name: 2026_PIPETISAR_RESEARCH
// Cell name: PIPE_SAR9_Real
// View name: schematic
// End of subcircuit definition.

// Library name: tcbn28hpcplusbwp12t30p140ulvt
// Cell name: ND2D0BWP12T30P140ULVT
// View name: schematic
// End of subcircuit definition.

// Library name: tsmcN28
// Cell name: trans_ulvt_mac
// View name: schematic
// End of subcircuit definition.

// Library name: 2026_PIPETISAR_RESEARCH
// Cell name: L4_stage1_flash_comparator
// View name: schematic
// End of subcircuit definition.

// Library name: 2026_PIPETISAR_RESEARCH
// Cell name: L4_stage1_flash_bootstrapper
// View name: schematic
// End of subcircuit definition.

// Library name: 2026_PIPETISAR_RESEARCH
// Cell name: L4_stage1_flash_clkbooster
// View name: schematic
// End of subcircuit definition.

// Library name: 2026_PIPETISAR_RESEARCH
// Cell name: L4_stage1_flash4_encoder
// View name: schematic
// End of subcircuit definition.

// Library name: 2026_PIPETISAR_RESEARCH
// Cell name: L4_stage1_flash4_rdac_FS2
// View name: schematic
// End of subcircuit definition.

// Library name: 2026_PIPETISAR_RESEARCH
// Cell name: L3_stage1_flash4_FS2
// View name: schematic
// End of subcircuit definition.

// Library name: 2026_PIPETISAR_RESEARCH
// Cell name: PIPE_TOP_F4_TI2_RS9
// View name: schematic
subckt PIPE_TOP_F4_TI2_RS9 AMP BIN_3 BIN_2 BIN_1 BIN_0 CHANNEL CODE_11 \
        CODE_10 CODE_9 CODE_8 CODE_7 CODE_6 CODE_5 CODE_4 CODE_3 CODE_2 \
        CODE_1 CODE_0 D_14 D_13 D_12 D_11 D_10 D_9 D_8 D_7 D_6 D_5 D_4 D_3 \
        D_2 D_1 D_0 DA DB IB_A IB_B OVERFLOW RECON RON ROP TA TB TRACK \
        VALID VCM VDD VINN VINP VREFN VREFP VSS
    XDAC (D_14 D_13 D_12 D_11 D_10 D_9 D_8 D_7 D_6 D_5 D_4 D_3 D_2 D_1 D_0 \
        DACP DACN K_3 K_2 K_1 K_0 VCM VREFP VREFN VDD VSS) \
        PIPE_ThermDAC4_FS2
    S_BN (RON HBN TB) Switch Rseries=50
    S_BP (ROP HBP TB) Switch Rseries=50
    S_AN (RON HAN TA) Switch Rseries=50
    S_AP (ROP HAP TA) Switch Rseries=50
    XRA (AMP DACN DACP RESET RON ROP TRACK VCM VDD VINN VINP VSS) \
        PIPE_MDAC4_G8_SC
    XCLK (TRACK AMP RESET TA TB PHI1EN PHI1N PHI2P PHI2N VDD VSS) \
        PIPE_Clock250_250_500 tper=Tper ttrack=Ttrack tamp=Tamp \
        guard=Tguard tr=TrModel
    XSARB (BUSYB DB K_3 K_2 K_1 K_0 KB_3 KB_2 KB_1 KB_0 OFB QB_8 QB_7 QB_6 \
        QB_5 QB_4 QB_3 QB_2 QB_1 QB_0 STEPB TB VCM VDACB VDD VHB HBN HBP \
        VREFN VREFP VSS) PIPE_SAR9_Real
    XSARA (BUSYA DA K_3 K_2 K_1 K_0 KA_3 KA_2 KA_1 KA_0 OFA QA_8 QA_7 QA_6 \
        QA_5 QA_4 QA_3 QA_2 QA_1 QA_0 STEPA TA VCM VDACA VDD VHA HAN HAP \
        VREFN VREFP VSS) PIPE_SAR9_Real
    CPROBE7 (BUSYB VSS) capacitor c=1a
    CPROBE6 (BUSYA VSS) capacitor c=1a
    CPROBE5 (STEPB VSS) capacitor c=1a
    CPROBE4 (STEPA VSS) capacitor c=1a
    CPROBE3 (VHB VSS) capacitor c=1a
    CPROBE2 (VHA VSS) capacitor c=1a
    CPROBE1 (VDACB VSS) capacitor c=1a
    CPROBE0 (VDACA VSS) capacitor c=1a
    C_BIN_3 (BIN_3 VSS) capacitor c=Cflash
    C_BIN_2 (BIN_2 VSS) capacitor c=Cflash
    C_BIN_1 (BIN_1 VSS) capacitor c=Cflash
    C_BIN_0 (BIN_0 VSS) capacitor c=Cflash
    C_DN_14 (DN_14 VSS) capacitor c=Cflash
    C_DN_13 (DN_13 VSS) capacitor c=Cflash
    C_DN_12 (DN_12 VSS) capacitor c=Cflash
    C_DN_11 (DN_11 VSS) capacitor c=Cflash
    C_DN_10 (DN_10 VSS) capacitor c=Cflash
    C_DN_9 (DN_9 VSS) capacitor c=Cflash
    C_DN_8 (DN_8 VSS) capacitor c=Cflash
    C_DN_7 (DN_7 VSS) capacitor c=Cflash
    C_DN_6 (DN_6 VSS) capacitor c=Cflash
    C_DN_5 (DN_5 VSS) capacitor c=Cflash
    C_DN_4 (DN_4 VSS) capacitor c=Cflash
    C_DN_3 (DN_3 VSS) capacitor c=Cflash
    C_DN_2 (DN_2 VSS) capacitor c=Cflash
    C_DN_1 (DN_1 VSS) capacitor c=Cflash
    C_DN_0 (DN_0 VSS) capacitor c=Cflash
    C_DP_14 (DP_14 VSS) capacitor c=Cflash
    C_DP_13 (DP_13 VSS) capacitor c=Cflash
    C_DP_12 (DP_12 VSS) capacitor c=Cflash
    C_DP_11 (DP_11 VSS) capacitor c=Cflash
    C_DP_10 (DP_10 VSS) capacitor c=Cflash
    C_DP_9 (DP_9 VSS) capacitor c=Cflash
    C_DP_8 (DP_8 VSS) capacitor c=Cflash
    C_DP_7 (DP_7 VSS) capacitor c=Cflash
    C_DP_6 (DP_6 VSS) capacitor c=Cflash
    C_DP_5 (DP_5 VSS) capacitor c=Cflash
    C_DP_4 (DP_4 VSS) capacitor c=Cflash
    C_DP_3 (DP_3 VSS) capacitor c=Cflash
    C_DP_2 (DP_2 VSS) capacitor c=Cflash
    C_DP_1 (DP_1 VSS) capacitor c=Cflash
    C_DP_0 (DP_0 VSS) capacitor c=Cflash
    C_D_14 (D_14 VSS) capacitor c=Cflash
    C_D_13 (D_13 VSS) capacitor c=Cflash
    C_D_12 (D_12 VSS) capacitor c=Cflash
    C_D_11 (D_11 VSS) capacitor c=Cflash
    C_D_10 (D_10 VSS) capacitor c=Cflash
    C_D_9 (D_9 VSS) capacitor c=Cflash
    C_D_8 (D_8 VSS) capacitor c=Cflash
    C_D_7 (D_7 VSS) capacitor c=Cflash
    C_D_6 (D_6 VSS) capacitor c=Cflash
    C_D_5 (D_5 VSS) capacitor c=Cflash
    C_D_4 (D_4 VSS) capacitor c=Cflash
    C_D_3 (D_3 VSS) capacitor c=Cflash
    C_D_2 (D_2 VSS) capacitor c=Cflash
    C_D_1 (D_1 VSS) capacitor c=Cflash
    C_D_0 (D_0 VSS) capacitor c=Cflash
    CH_BN (HBN VCM) capacitor c=Cs2
    CH_BP (HBP VCM) capacitor c=Cs2
    CH_AN (HAN VCM) capacitor c=Cs2
    CH_AP (HAP VCM) capacitor c=Cs2
    XMERGE (QA_8 QA_7 QA_6 QA_5 QA_4 QA_3 QA_2 QA_1 QA_0 QB_8 QB_7 QB_6 \
        QB_5 QB_4 QB_3 QB_2 QB_1 QB_0 KA_3 KA_2 KA_1 KA_0 KB_3 KB_2 KB_1 \
        KB_0 DA DB OFA OFB CODE_11 CODE_10 CODE_9 CODE_8 CODE_7 CODE_6 \
        CODE_5 CODE_4 CODE_3 CODE_2 CODE_1 CODE_0 VALID CHANNEL OVERFLOW \
        RECON VDD VSS) PIPE_Merge12 vfs=Vref tr=TrModel
    XFLASH (BIN_3 BIN_2 BIN_1 BIN_0 D_14 D_13 D_12 D_11 D_10 D_9 D_8 D_7 \
        D_6 D_5 D_4 D_3 D_2 D_1 D_0 DN_14 DN_13 DN_12 DN_11 DN_10 DN_9 \
        DN_8 DN_7 DN_6 DN_5 DN_4 DN_3 DN_2 DN_1 DN_0 DP_14 DP_13 DP_12 \
        DP_11 DP_10 DP_9 DP_8 DP_7 DP_6 DP_5 DP_4 DP_3 DP_2 DP_1 DP_0 IB_A \
        IB_B PHI1EN PHI1N PHI2N PHI2P VCM VDD VINN VINP VCM VCM VCM VCM \
        VCM VCM VCM VCM VCM VCM VCM VCM VCM VCM VCM VCM VCM VCM VCM VCM \
        VCM VCM VCM VCM VCM VCM VCM VCM VCM VCM VREFN VREFP VSS) \
        L3_stage1_flash4_FS2
// @RNL(author="rnl-virtuoso") {
//   %block_symbol = @DEFINE-SYMBOL(box=[0, -58.4, 59.2, 2.4]) {
//     @RECTANGLE {(0, -58.4) (59.2, 2.4)};
//     (29.6, 6.7) @TEXT("PIPE ADC / 12b", size=3.2, halign="middle", valign="middle");
//     ? @TEXT("${name}", size=1.9, halign="middle", valign="middle", key="name") => @PLACE(29.6, -62.4);
//     (59.2, -56) @PIN(terminal="CHANNEL");
//     (57.6, -56) @TEXT("CHANNEL", size=2.6, halign="end", valign="middle");
//     (59.2, -52) @PIN(terminal="DB");
//     (57.6, -52) @TEXT("DB", size=2.6, halign="end", valign="middle");
//     (59.2, -48) @PIN(terminal="DA");
//     (57.6, -48) @TEXT("DA", size=2.6, halign="end", valign="middle");
//     (59.2, -44) @PIN(terminal="TB");
//     (57.6, -44) @TEXT("TB", size=2.6, halign="end", valign="middle");
//     (59.2, -40) @PIN(terminal="TA");
//     (57.6, -40) @TEXT("TA", size=2.6, halign="end", valign="middle");
//     (59.2, -36) @PIN(terminal="AMP");
//     (57.6, -36) @TEXT("AMP", size=2.6, halign="end", valign="middle");
//     (59.2, -32) @PIN(terminal="TRACK");
//     (57.6, -32) @TEXT("TRACK", size=2.6, halign="end", valign="middle");
//     (59.2, -28) @PIN(terminal=["BIN_3", "BIN_2", "BIN_1", "BIN_0"]);
//     (57.6, -28) @TEXT("BIN<3:0>", size=2.6, halign="end", valign="middle");
//     (59.2, -4) @PIN(terminal="RECON");
//     (57.6, -4) @TEXT("RECON", size=2.6, halign="end", valign="middle");
//     (59.2, -8) @PIN(terminal="VALID");
//     (57.6, -8) @TEXT("VALID", size=2.6, halign="end", valign="middle");
//     (59.2, -12) @PIN(terminal="OVERFLOW");
//     (57.6, -12) @TEXT("OVERFLOW", size=2.6, halign="end", valign="middle");
//     (59.2, -16) @PIN(terminal="ROP");
//     (57.6, -16) @TEXT("ROP", size=2.6, halign="end", valign="middle");
//     (59.2, -20) @PIN(terminal="RON");
//     (57.6, -20) @TEXT("RON", size=2.6, halign="end", valign="middle");
//     (59.2, -24) @PIN(terminal=["D_14", "D_13", "D_12", "D_11", "D_10", "D_9", "D_8", "D_7", "D_6", "D_5", "D_4", "D_3", "D_2", "D_1", "D_0"]);
//     (57.6, -24) @TEXT("D<14:0>", size=2.6, halign="end", valign="middle");
//     (0, -28) @PIN(terminal="IB_A");
//     (1.6, -28) @TEXT("IB\_A", size=2.6, halign="start", valign="middle");
//     (0, -32) @PIN(terminal="IB_B");
//     (1.6, -32) @TEXT("IB\_B", size=2.6, halign="start", valign="middle");
//     (59.2, 0) @PIN(terminal=["CODE_11", "CODE_10", "CODE_9", "CODE_8", "CODE_7", "CODE_6", "CODE_5", "CODE_4", "CODE_3", "CODE_2", "CODE_1", "CODE_0"]);
//     (57.6, 0) @TEXT("CODE<11:0>", size=2.6, halign="end", valign="middle");
//     (0, -24) @PIN(terminal="VSS");
//     (1.6, -24) @TEXT("VSS", size=2.6, halign="start", valign="middle");
//     (0, -20) @PIN(terminal="VDD");
//     (1.6, -20) @TEXT("VDD", size=2.6, halign="start", valign="middle");
//     (0, -16) @PIN(terminal="VCM");
//     (1.6, -16) @TEXT("VCM", size=2.6, halign="start", valign="middle");
//     (0, -12) @PIN(terminal="VREFN");
//     (1.6, -12) @TEXT("VREFN", size=2.6, halign="start", valign="middle");
//     (0, -8) @PIN(terminal="VREFP");
//     (1.6, -8) @TEXT("VREFP", size=2.6, halign="start", valign="middle");
//     (0, -4) @PIN(terminal="VINN");
//     (1.6, -4) @TEXT("VINN", size=2.6, halign="start", valign="middle");
//     (0, 0) @PIN(terminal="VINP");
//     (1.6, 0) @TEXT("VINP", size=2.6, halign="start", valign="middle")
//   };
//   # @SET-SYMBOL %block_symbol;
//   #"CH_AP" @SET-SYMBOL $CAPACITOR;
//   #"CH_AP" @PLACE(227.2, 9.8) => @ORIENT("R0");
//   #"CPROBE6" @SET-SYMBOL $CAPACITOR;
//   #"CPROBE6" @PLACE(326.4, -131) => @ORIENT("R0");
//   #"S_BN" @PLACE(196, -97.6) => @ORIENT("R0");
//   %symbol_0 = @DEFINE-SYMBOL(box=[0, -38.4, 48, 2.4]) {
//     @RECTANGLE {(0, -38.4) (48, 2.4)};
//     (24, 6.7) @TEXT("ALIGN + MERGE", size=3.2, halign="middle", valign="middle");
//     ? @TEXT("${name}", size=1.9, halign="middle", valign="middle", key="name") => @PLACE(24, -42.4);
//     (48, -16) @PIN(terminal=45);
//     (46.4, -16) @TEXT("OVF", size=2.6, halign="end", valign="middle");
//     (48, -12) @PIN(terminal=44);
//     (46.4, -12) @TEXT("CHANNEL", size=2.6, halign="end", valign="middle");
//     (48, -8) @PIN(terminal=43);
//     (46.4, -8) @TEXT("VALID", size=2.6, halign="end", valign="middle");
//     (48, -4) @PIN(terminal=46);
//     (46.4, -4) @TEXT("RECON", size=2.6, halign="end", valign="middle");
//     (0, -28) @PIN(terminal=30);
//     (1.6, -28) @TEXT("OFB", size=2.6, halign="start", valign="middle");
//     (0, -32) @PIN(terminal=47);
//     (1.6, -32) @TEXT("VDD", size=2.6, halign="start", valign="middle");
//     (0, -36) @PIN(terminal=48);
//     (1.6, -36) @TEXT("VSS", size=2.6, halign="start", valign="middle");
//     (48, 0) @PIN(terminal=[31, 32, 33, 34, 35, 36, 37, 38, 39, 40, 41, 42]);
//     (46.4, 0) @TEXT("CODE<11:0>", size=2.6, halign="end", valign="middle");
//     (0, -24) @PIN(terminal=28);
//     (1.6, -24) @TEXT("DB", size=2.6, halign="start", valign="middle");
//     (0, -20) @PIN(terminal=[23, 24, 25, 26]);
//     (1.6, -20) @TEXT("KB<3:0>", size=2.6, halign="start", valign="middle");
//     (0, -16) @PIN(terminal=[10, 11, 12, 13, 14, 15, 16, 17, 18]);
//     (1.6, -16) @TEXT("QB<8:0>", size=2.6, halign="start", valign="middle");
//     (0, -8) @PIN(terminal=27);
//     (1.6, -8) @TEXT("DA", size=2.6, halign="start", valign="middle");
//     (0, -12) @PIN(terminal=29);
//     (1.6, -12) @TEXT("OFA", size=2.6, halign="start", valign="middle");
//     (0, -4) @PIN(terminal=[19, 20, 21, 22]);
//     (1.6, -4) @TEXT("KA<3:0>", size=2.6, halign="start", valign="middle");
//     (0, 0) @PIN(terminal=[1, 2, 3, 4, 5, 6, 7, 8, 9]);
//     (1.6, 0) @TEXT("QA<8:0>", size=2.6, halign="start", valign="middle")
//   };
//   #"XMERGE" @SET-SYMBOL %symbol_0;
//   #"XMERGE" @PLACE(336, 0) => @ORIENT("R0");
//   #"XSARA" @PLACE(256, 16) => @ORIENT("R0");
//   #"CPROBE2" @SET-SYMBOL $CAPACITOR;
//   #"CPROBE2" @PLACE(236.8, -131) => @ORIENT("R0");
//   #"XSARB" @PLACE(256, -68.8) => @ORIENT("R0");
//   %bundle_0 = {#"C_D_14" #"C_D_13" #"C_D_12" #"C_D_11" #"C_D_10" #"C_D_9" #"C_D_8" #"C_D_7" #"C_D_6" #"C_D_5" #"C_D_4" #"C_D_3" #"C_D_2" #"C_D_1" #"C_D_0"} @BUNDLE;
//   %bundle_0 @SET-SYMBOL $CAPACITOR;
//   %bundle_0 @PLACE(72, -131) => @ORIENT("R0");
//   %bundle_0 @TEXT("C\_D<14:0>", key="name");
//   #"XRA" @PLACE(136, 0) => @ORIENT("R0");
//   #"CPROBE1" @SET-SYMBOL $CAPACITOR;
//   #"CPROBE1" @PLACE(214.4, -131) => @ORIENT("R0");
//   #"CH_BP" @SET-SYMBOL $CAPACITOR;
//   #"CH_BP" @PLACE(227.2, -75) => @ORIENT("R0");
//   #"CPROBE7" @SET-SYMBOL $CAPACITOR;
//   #"CPROBE7" @PLACE(348.8, -131) => @ORIENT("R0");
//   #"CH_AN" @SET-SYMBOL $CAPACITOR;
//   #"CH_AN" @PLACE(227.2, -15.8) => @ORIENT("R0");
//   %symbol_1 = @DEFINE-SYMBOL(box=[0, -56, 57.6, 4.8]) {
//     @RECTANGLE {(0, -56) (57.6, 4.8)};
//     (28.8, 10.4) @TEXT("COARSE DAC", size=4.6, halign="middle", valign="middle");
//     ? @TEXT("${name}", size=3.8, halign="middle", valign="middle", key="name") => @PLACE(28.8, -61.1);
//     (0, -8) @PIN(terminal=23);
//     (2.2, -8) @TEXT("VREFP", size=3.8, halign="start", valign="middle");
//     (0, -16) @PIN(terminal=24);
//     (2.2, -16) @TEXT("VREFN", size=3.8, halign="start", valign="middle");
//     (0, -24) @PIN(terminal=22);
//     (2.2, -24) @TEXT("VCM", size=3.8, halign="start", valign="middle");
//     (0, -32) @PIN(terminal=25);
//     (2.2, -32) @TEXT("VDD", size=3.8, halign="start", valign="middle");
//     (0, -40) @PIN(terminal=26);
//     (2.2, -40) @TEXT("VSS", size=3.8, halign="start", valign="middle");
//     (57.6, 0) @PIN(terminal=16);
//     (55.4, 0) @TEXT("VP", size=3.8, halign="end", valign="middle");
//     (57.6, -12.8) @PIN(terminal=17);
//     (55.4, -12.8) @TEXT("VN", size=3.8, halign="end", valign="middle");
//     (57.6, -51.2) @PIN(terminal=[18, 19, 20, 21]);
//     (55.4, -51.2) @TEXT("K<3:0>", size=3.8, halign="end", valign="middle");
//     (0, 0) @PIN(terminal=[1, 2, 3, 4, 5, 6, 7, 8, 9, 10, 11, 12, 13, 14, 15]);
//     (2.2, 0) @TEXT("D<14:0>", size=3.8, halign="start", valign="middle")
//   };
//   #"XDAC" @SET-SYMBOL %symbol_1;
//   #"XDAC" @PLACE(72, -32) => @ORIENT("R0");
//   #"CPROBE5" @SET-SYMBOL $CAPACITOR;
//   #"CPROBE5" @PLACE(304, -131) => @ORIENT("R0");
//   #"S_AN" @PLACE(196, -12.8) => @ORIENT("R0");
//   #"CH_BN" @SET-SYMBOL $CAPACITOR;
//   #"CH_BN" @PLACE(227.2, -100.6) => @ORIENT("R0");
//   %bundle_1 = {#"C_DP_14" #"C_DP_13" #"C_DP_12" #"C_DP_11" #"C_DP_10" #"C_DP_9" #"C_DP_8" #"C_DP_7" #"C_DP_6" #"C_DP_5" #"C_DP_4" #"C_DP_3" #"C_DP_2" #"C_DP_1" #"C_DP_0"} @BUNDLE;
//   %bundle_1 @SET-SYMBOL $CAPACITOR;
//   %bundle_1 @PLACE(96, -131) => @ORIENT("R0");
//   %bundle_1 @TEXT("C\_DP<14:0>", key="name");
//   #"CPROBE3" @SET-SYMBOL $CAPACITOR;
//   #"CPROBE3" @PLACE(259.2, -131) => @ORIENT("R0");
//   #"CPROBE4" @SET-SYMBOL $CAPACITOR;
//   #"CPROBE4" @PLACE(281.6, -131) => @ORIENT("R0");
//   #"XFLASH" @PLACE(0, 0) => @ORIENT("R0");
//   #"S_BP" @PLACE(196, -72) => @ORIENT("R0");
//   %symbol_2 = @DEFINE-SYMBOL(box=[0, -68.8, 70.4, 4.8]) {
//     @RECTANGLE {(0, -68.8) (70.4, 4.8)};
//     (35.2, 10.4) @TEXT("CLOCK PHASES", size=4.6, halign="middle", valign="middle");
//     ? @TEXT("${name}", size=3.8, halign="middle", valign="middle", key="name") => @PLACE(35.2, -73.9);
//     (0, 0) @PIN(terminal=10);
//     (2.2, 0) @TEXT("VDD", size=3.8, halign="start", valign="middle");
//     (0, -8) @PIN(terminal=11);
//     (2.2, -8) @TEXT("VSS", size=3.8, halign="start", valign="middle");
//     (70.4, 0) @PIN(terminal=1);
//     (68.2, 0) @TEXT("TRACK", size=3.8, halign="end", valign="middle");
//     (70.4, -8) @PIN(terminal=6);
//     (68.2, -8) @TEXT("PHI1EN", size=3.8, halign="end", valign="middle");
//     (70.4, -16) @PIN(terminal=7);
//     (68.2, -16) @TEXT("PHI1N", size=3.8, halign="end", valign="middle");
//     (70.4, -24) @PIN(terminal=8);
//     (68.2, -24) @TEXT("PHI2P", size=3.8, halign="end", valign="middle");
//     (70.4, -32) @PIN(terminal=9);
//     (68.2, -32) @TEXT("PHI2N", size=3.8, halign="end", valign="middle");
//     (70.4, -40) @PIN(terminal=2);
//     (68.2, -40) @TEXT("AMP", size=3.8, halign="end", valign="middle");
//     (70.4, -48) @PIN(terminal=3);
//     (68.2, -48) @TEXT("RESET", size=3.8, halign="end", valign="middle");
//     (70.4, -56) @PIN(terminal=4);
//     (68.2, -56) @TEXT("TA", size=3.8, halign="end", valign="middle");
//     (70.4, -64) @PIN(terminal=5);
//     (68.2, -64) @TEXT("TB", size=3.8, halign="end", valign="middle")
//   };
//   #"XCLK" @SET-SYMBOL %symbol_2;
//   #"XCLK" @PLACE(0, -80) => @ORIENT("R0");
//   #"S_AP" @PLACE(196, 12.8) => @ORIENT("R0");
//   #"CPROBE0" @SET-SYMBOL $CAPACITOR;
//   #"CPROBE0" @PLACE(192, -131) => @ORIENT("R0");
//   %bundle_2 = {#"C_DN_14" #"C_DN_13" #"C_DN_12" #"C_DN_11" #"C_DN_10" #"C_DN_9" #"C_DN_8" #"C_DN_7" #"C_DN_6" #"C_DN_5" #"C_DN_4" #"C_DN_3" #"C_DN_2" #"C_DN_1" #"C_DN_0"} @BUNDLE;
//   %bundle_2 @SET-SYMBOL $CAPACITOR;
//   %bundle_2 @PLACE(120, -131) => @ORIENT("R0");
//   %bundle_2 @TEXT("C\_DN<14:0>", key="name");
//   %bundle_3 = {#"C_BIN_3" #"C_BIN_2" #"C_BIN_1" #"C_BIN_0"} @BUNDLE;
//   %bundle_3 @SET-SYMBOL $CAPACITOR;
//   %bundle_3 @PLACE(144, -131) => @ORIENT("R0");
//   %bundle_3 @TEXT("C\_BIN<3:0>", key="name");
//   %output_port_symbol = @DEFINE-SYMBOL(box=[0, -1, 2, 1]) {
//       @LINE(fill="linecolor", linestyle="none") {(0, -0.9) (0, 0.9) (1.1, 0.9) (2, 0) (1.1, -0.9) (0, -0.9)};
//       (0, 0) @PIN(terminal=1, direction="left");
//       ? @TEXT("${name}", key="name", halign="middle") => @PLACE(1, 1.6)
//     };
//   %port_0 = $IO_PORT @ATTACH &"DB" => @PLACE(341.6, -196.8) => @ORIENT("R0");
//   %port_0 @SET-SYMBOL %output_port_symbol;
//   %port_0 @TEXT("DB", key="name");
//   %port_1 = $IO_PORT @ATTACH &"DA" => @PLACE(292.8, -196.8) => @ORIENT("R0");
//   %port_1 @SET-SYMBOL %output_port_symbol;
//   %port_1 @TEXT("DA", key="name");
//   %port_2 = $IO_PORT @ATTACH &"TB" => @PLACE(244, -196.8) => @ORIENT("R0");
//   %port_2 @SET-SYMBOL %output_port_symbol;
//   %port_2 @TEXT("TB", key="name");
//   %port_3 = $IO_PORT @ATTACH &"TA" => @PLACE(195.2, -196.8) => @ORIENT("R0");
//   %port_3 @SET-SYMBOL %output_port_symbol;
//   %port_3 @TEXT("TA", key="name");
//   %port_4 = $IO_PORT @ATTACH &"AMP" => @PLACE(146.4, -196.8) => @ORIENT("R0");
//   %port_4 @SET-SYMBOL %output_port_symbol;
//   %port_4 @TEXT("AMP", key="name");
//   %port_5 = $IO_PORT @ATTACH &"TRACK" => @PLACE(97.6, -196.8) => @ORIENT("R0");
//   %port_5 @SET-SYMBOL %output_port_symbol;
//   %port_5 @TEXT("TRACK", key="name");
//   %bus_port_type_6 = @DEFINE(roles=[["p", "net"], ["p1", "net"], ["p2", "net"], ["p3", "net"]]) {};
//   %bus_port_type_6_symbol = @DEFINE-SYMBOL {(0, 0) @PIN(terminal=[1, 2, 3, 4])};
//   {&"BIN_3" &"BIN_2" &"BIN_1" &"BIN_0"} @REMOVE-FROM $PORT_FILL_SET;
//   %port_6 = %bus_port_type_6 @ATTACH &"BIN_3" &"BIN_2" &"BIN_1" &"BIN_0" => @PLACE(48.8, -196.8) => @ORIENT("R0");
//   %port_6 @SET-SYMBOL %bus_port_type_6_symbol;
//   %port_6_marker = $IO_PORT @ATTACH &"BIN_3" => @PLACE(48.8, -196.8) => @ORIENT("R0");
//   %port_6_marker @SET-SYMBOL %output_port_symbol;
//   %port_6_marker @TEXT("BIN<3:0>", key="name");
//   %bus_port_type_7 = @DEFINE(roles=[["p", "net"], ["p1", "net"], ["p2", "net"], ["p3", "net"], ["p4", "net"], ["p5", "net"], ["p6", "net"], ["p7", "net"], ["p8", "net"], ["p9", "net"], ["p10", "net"], ["p11", "net"], ["p12", "net"], ["p13", "net"], ["p14", "net"]]) {};
//   %bus_port_type_7_symbol = @DEFINE-SYMBOL {(0, 0) @PIN(terminal=[1, 2, 3, 4, 5, 6, 7, 8, 9, 10, 11, 12, 13, 14, 15])};
//   {&"D_14" &"D_13" &"D_12" &"D_11" &"D_10" &"D_9" &"D_8" &"D_7" &"D_6" &"D_5" &"D_4" &"D_3" &"D_2" &"D_1" &"D_0"} @REMOVE-FROM $PORT_FILL_SET;
//   %port_7 = %bus_port_type_7 @ATTACH &"D_14" &"D_13" &"D_12" &"D_11" &"D_10" &"D_9" &"D_8" &"D_7" &"D_6" &"D_5" &"D_4" &"D_3" &"D_2" &"D_1" &"D_0" => @PLACE(0, -196.8) => @ORIENT("R0");
//   %port_7 @SET-SYMBOL %bus_port_type_7_symbol;
//   %port_7_marker = $IO_PORT @ATTACH &"D_14" => @PLACE(0, -196.8) => @ORIENT("R0");
//   %port_7_marker @SET-SYMBOL %output_port_symbol;
//   %port_7_marker @TEXT("D<14:0>", key="name");
//   %port_8 = $IO_PORT @ATTACH &"RON" => @PLACE(341.6, -187.2) => @ORIENT("R0");
//   %port_8 @SET-SYMBOL %output_port_symbol;
//   %port_8 @TEXT("RON", key="name");
//   %port_9 = $IO_PORT @ATTACH &"ROP" => @PLACE(292.8, -187.2) => @ORIENT("R0");
//   %port_9 @SET-SYMBOL %output_port_symbol;
//   %port_9 @TEXT("ROP", key="name");
//   %port_10 = $IO_PORT @ATTACH &"VALID" => @PLACE(97.6, -187.2) => @ORIENT("R0");
//   %port_10 @SET-SYMBOL %output_port_symbol;
//   %port_10 @TEXT("VALID", key="name");
//   %port_11 = $IO_PORT @ATTACH &"RECON" => @PLACE(146.4, -187.2) => @ORIENT("R0");
//   %port_11 @SET-SYMBOL %output_port_symbol;
//   %port_11 @TEXT("RECON", key="name");
//   %port_12 = $IO_PORT @ATTACH &"CHANNEL" => @PLACE(195.2, -187.2) => @ORIENT("R0");
//   %port_12 @SET-SYMBOL %output_port_symbol;
//   %port_12 @TEXT("CHANNEL", key="name");
//   %port_13 = $IO_PORT @ATTACH &"OVERFLOW" => @PLACE(244, -187.2) => @ORIENT("R0");
//   %port_13 @SET-SYMBOL %output_port_symbol;
//   %port_13 @TEXT("OVERFLOW", key="name");
//   %bus_port_type_14 = @DEFINE(roles=[["p", "net"], ["p1", "net"], ["p2", "net"], ["p3", "net"], ["p4", "net"], ["p5", "net"], ["p6", "net"], ["p7", "net"], ["p8", "net"], ["p9", "net"], ["p10", "net"], ["p11", "net"]]) {};
//   %bus_port_type_14_symbol = @DEFINE-SYMBOL {(0, 0) @PIN(terminal=[1, 2, 3, 4, 5, 6, 7, 8, 9, 10, 11, 12])};
//   {&"CODE_11" &"CODE_10" &"CODE_9" &"CODE_8" &"CODE_7" &"CODE_6" &"CODE_5" &"CODE_4" &"CODE_3" &"CODE_2" &"CODE_1" &"CODE_0"} @REMOVE-FROM $PORT_FILL_SET;
//   %port_14 = %bus_port_type_14 @ATTACH &"CODE_11" &"CODE_10" &"CODE_9" &"CODE_8" &"CODE_7" &"CODE_6" &"CODE_5" &"CODE_4" &"CODE_3" &"CODE_2" &"CODE_1" &"CODE_0" => @PLACE(48.8, -187.2) => @ORIENT("R0");
//   %port_14 @SET-SYMBOL %bus_port_type_14_symbol;
//   %port_14_marker = $IO_PORT @ATTACH &"CODE_11" => @PLACE(48.8, -187.2) => @ORIENT("R0");
//   %port_14_marker @SET-SYMBOL %output_port_symbol;
//   %port_14_marker @TEXT("CODE<11:0>", key="name");
//   %input_port_symbol = @DEFINE-SYMBOL(box=[-2, -1, 0, 1]) {
//       @LINE(fill="linecolor", linestyle="none") {(-2, -0.9) (-2, 0.9) (-0.9, 0.9) (0, 0) (-0.9, -0.9) (-2, -0.9)};
//       (0, 0) @PIN(terminal=1, direction="right");
//       ? @TEXT("${name}", key="name", halign="middle") => @PLACE(-1, 1.6)
//     };
//   %port_15 = $IO_PORT @ATTACH &"IB_B" => @PLACE(0, -187.2) => @ORIENT("R0");
//   %port_15 @SET-SYMBOL %input_port_symbol;
//   %port_15 @TEXT("IB\_B", key="name");
//   %port_16 = $IO_PORT @ATTACH &"IB_A" => @PLACE(341.6, -177.6) => @ORIENT("R0");
//   %port_16 @SET-SYMBOL %input_port_symbol;
//   %port_16 @TEXT("IB\_A", key="name");
//   %port_17 = $IO_PORT @ATTACH &"VREFN" => @PLACE(292.8, -177.6) => @ORIENT("R0");
//   %port_17 @SET-SYMBOL %input_port_symbol;
//   %port_17 @TEXT("VREFN", key="name");
//   %port_18 = $IO_PORT @ATTACH &"VREFP" => @PLACE(244, -177.6) => @ORIENT("R0");
//   %port_18 @SET-SYMBOL %input_port_symbol;
//   %port_18 @TEXT("VREFP", key="name");
//   %port_19 = $IO_PORT @ATTACH &"VCM" => @PLACE(195.2, -177.6) => @ORIENT("R0");
//   %port_19 @SET-SYMBOL %input_port_symbol;
//   %port_19 @TEXT("VCM", key="name");
//   %port_20 = $IO_PORT @ATTACH &"VSS" => @PLACE(146.4, -177.6) => @ORIENT("R0");
//   %port_20 @SET-SYMBOL %input_port_symbol;
//   %port_20 @TEXT("VSS", key="name");
//   %port_21 = $IO_PORT @ATTACH &"VDD" => @PLACE(97.6, -177.6) => @ORIENT("R0");
//   %port_21 @SET-SYMBOL %input_port_symbol;
//   %port_21 @TEXT("VDD", key="name");
//   %port_22 = $IO_PORT @ATTACH &"VINN" => @PLACE(48.8, -177.6) => @ORIENT("R0");
//   %port_22 @SET-SYMBOL %input_port_symbol;
//   %port_22 @TEXT("VINN", key="name");
//   %port_23 = $IO_PORT @ATTACH &"VINP" => @PLACE(0, -177.6) => @ORIENT("R0");
//   %port_23 @SET-SYMBOL %input_port_symbol;
//   %port_23 @TEXT("VINP", key="name");
//   %p0 = (259.2, -124.5);
//   %wire_0 = &"VHB" @WIRE(mode="straight") {#"CPROBE3":1 %p0};
//   %p1 = (301.1, -88.8);
//   %wire_1 = &"VHB" @WIRE(mode="straight") {#"XSARB":26 %p1};
//   %wire_1 @TEXT("VHB", size=2.4, halign="start", valign="middle") => @PLACE(302.7, -88.8);
//   %wire_0 @TEXT("VHB", size=1.9, halign="start", valign="baseline") => @PLACE(259.8, -124);
//   %p2 = (236.8, -124.5);
//   %wire_2 = &"VHA" @WIRE(mode="straight") {#"CPROBE2":1 %p2};
//   %p3 = (301.1, -4);
//   %wire_3 = &"VHA" @WIRE(mode="straight") {#"XSARA":26 %p3};
//   %wire_3 @TEXT("VHA", size=2.4, halign="start", valign="middle") => @PLACE(302.7, -4);
//   %wire_2 @TEXT("VHA", size=1.9, halign="start", valign="baseline") => @PLACE(237.4, -124);
//   %p4 = (214.4, -124.5);
//   %wire_4 = &"VDACB" @WIRE(mode="straight") {#"CPROBE1":1 %p4};
//   %p5 = (301.1, -92.8);
//   %wire_5 = &"VDACB" @WIRE(mode="straight") {#"XSARB":24 %p5};
//   %wire_5 @TEXT("VDACB", size=2.4, halign="start", valign="middle") => @PLACE(302.7, -92.8);
//   %wire_4 @TEXT("VDACB", size=1.9, halign="start", valign="baseline") => @PLACE(215, -124);
//   %p6 = (192, -124.5);
//   %wire_6 = &"VDACA" @WIRE(mode="straight") {#"CPROBE0":1 %p6};
//   %p7 = (301.1, -8);
//   %wire_7 = &"VDACA" @WIRE(mode="straight") {#"XSARA":24 %p7};
//   %wire_7 @TEXT("VDACA", size=2.4, halign="start", valign="middle") => @PLACE(302.7, -8);
//   %wire_6 @TEXT("VDACA", size=1.9, halign="start", valign="baseline") => @PLACE(192.6, -124);
//   %p8 = (304, -124.5);
//   %wire_8 = &"STEPB" @WIRE(mode="straight") {#"CPROBE5":1 %p8};
//   %p9 = (301.1, -96.8);
//   %wire_9 = &"STEPB" @WIRE(mode="straight") {#"XSARB":21 %p9};
//   %wire_9 @TEXT("STEPB", size=2.4, halign="start", valign="middle") => @PLACE(302.7, -96.8);
//   %wire_8 @TEXT("STEPB", size=1.9, halign="start", valign="baseline") => @PLACE(304.6, -124);
//   %p10 = (281.6, -124.5);
//   %wire_10 = &"STEPA" @WIRE(mode="straight") {#"CPROBE4":1 %p10};
//   %p11 = (301.1, -12);
//   %wire_11 = &"STEPA" @WIRE(mode="straight") {#"XSARA":21 %p11};
//   %wire_11 @TEXT("STEPA", size=2.4, halign="start", valign="middle") => @PLACE(302.7, -12);
//   %wire_10 @TEXT("STEPA", size=1.9, halign="start", valign="baseline") => @PLACE(282.2, -124);
//   %p12 = (316.8, -68.8);
//   %wire_12 = {&"QB_8" &"QB_7" &"QB_6" &"QB_5" &"QB_4" &"QB_3" &"QB_2" &"QB_1" &"QB_0"} @WIRE(mode="straight") {#"XSARB":12 %p12};
//   %p13 = (316.8, -16);
//   %wire_13 = {&"QB_8" &"QB_7" &"QB_6" &"QB_5" &"QB_4" &"QB_3" &"QB_2" &"QB_1" &"QB_0"} @WIRE(mode="straight") {%p12 %p13};
//   %wire_14 = {&"QB_8" &"QB_7" &"QB_6" &"QB_5" &"QB_4" &"QB_3" &"QB_2" &"QB_1" &"QB_0"} @WIRE(mode="straight") {%p13 #"XMERGE":10};
//   %wire_12 @TEXT("QB<8:0>", size=2.4, halign="middle", valign="baseline") => @PLACE(307.2, -68.8);
//   %p14 = (-3.5, -6);
//   %wire_15 = &"PHI2P" @WIRE(mode="straight") {%p14 #"XFLASH":55};
//   %p15 = (40.3, -92);
//   %wire_16 = &"PHI2P" @WIRE(mode="straight") {#"XCLK":8 %p15};
//   %wire_16 @TEXT("PHI2P", size=2.4, halign="start", valign="middle") => @PLACE(41.9, -92);
//   %wire_15 @TEXT("PHI2P", size=1.4, halign="end", valign="middle") => @PLACE(-5.1, -6);
//   %p16 = (-3.5, -4);
//   %wire_17 = &"PHI2N" @WIRE(mode="straight") {%p16 #"XFLASH":54};
//   %p17 = (40.3, -96);
//   %wire_18 = &"PHI2N" @WIRE(mode="straight") {#"XCLK":9 %p17};
//   %wire_18 @TEXT("PHI2N", size=2.4, halign="start", valign="middle") => @PLACE(41.9, -96);
//   %wire_17 @TEXT("PHI2N", size=1.4, halign="end", valign="middle") => @PLACE(-5.1, -4);
//   %p18 = (-3.5, -2);
//   %wire_19 = &"PHI1N" @WIRE(mode="straight") {%p18 #"XFLASH":53};
//   %p19 = (40.3, -88);
//   %wire_20 = &"PHI1N" @WIRE(mode="straight") {#"XCLK":7 %p19};
//   %wire_20 @TEXT("PHI1N", size=2.4, halign="start", valign="middle") => @PLACE(41.9, -88);
//   %wire_19 @TEXT("PHI1N", size=1.4, halign="end", valign="middle") => @PLACE(-5.1, -2);
//   %p20 = (-3.5, 0);
//   %wire_21 = &"PHI1EN" @WIRE(mode="straight") {%p20 #"XFLASH":52};
//   %p21 = (40.3, -84);
//   %wire_22 = &"PHI1EN" @WIRE(mode="straight") {#"XCLK":6 %p21};
//   %wire_22 @TEXT("PHI1EN", size=2.4, halign="start", valign="middle") => @PLACE(41.9, -84);
//   %wire_21 @TEXT("PHI1EN", size=1.4, halign="end", valign="middle") => @PLACE(-5.1, 0);
//   %wire_23 = &"HBP" @WIRE(mode="straight") {#"S_BP":2 #"CH_BP":1};
//   %p22 = (241.6, -72);
//   %wire_24 = &"HBP" @WIRE(mode="straight") {#"CH_BP":1 %p22};
//   %p23 = (241.6, -68.8);
//   %wire_25 = &"HBP" @WIRE(mode="straight") {%p22 %p23};
//   %wire_26 = &"HBP" @WIRE(mode="straight") {%p23 #"XSARB":28};
//   %wire_24 @TEXT("HBP", size=2.4, halign="middle", valign="baseline") => @PLACE(234.4, -72);
//   %wire_23 @TEXT("HBP", size=2.4, halign="middle", valign="baseline") => @PLACE(216.8, -72);
//   %wire_27 = &"HBN" @WIRE(mode="straight") {#"S_BN":2 #"CH_BN":1};
//   %p24 = (241.6, -97.6);
//   %wire_28 = &"HBN" @WIRE(mode="straight") {#"CH_BN":1 %p24};
//   %p25 = (241.6, -72.8);
//   %wire_29 = &"HBN" @WIRE(mode="straight") {%p24 %p25};
//   %wire_30 = &"HBN" @WIRE(mode="straight") {%p25 #"XSARB":27};
//   %wire_28 @TEXT("HBN", size=2.4, halign="middle", valign="baseline") => @PLACE(234.4, -97.6);
//   %wire_27 @TEXT("HBN", size=2.4, halign="middle", valign="baseline") => @PLACE(216.8, -97.6);
//   %wire_31 = &"HAP" @WIRE(mode="straight") {#"S_AP":2 #"CH_AP":1};
//   %p26 = (241.6, 12.8);
//   %wire_32 = &"HAP" @WIRE(mode="straight") {#"CH_AP":1 %p26};
//   %p27 = (241.6, 16);
//   %wire_33 = &"HAP" @WIRE(mode="straight") {%p26 %p27};
//   %wire_34 = &"HAP" @WIRE(mode="straight") {%p27 #"XSARA":28};
//   %wire_32 @TEXT("HAP", size=2.4, halign="middle", valign="baseline") => @PLACE(234.4, 12.8);
//   %wire_31 @TEXT("HAP", size=2.4, halign="middle", valign="baseline") => @PLACE(216.8, 12.8);
//   %wire_35 = &"HAN" @WIRE(mode="straight") {#"S_AN":2 #"CH_AN":1};
//   %p28 = (241.6, -12.8);
//   %wire_36 = &"HAN" @WIRE(mode="straight") {#"CH_AN":1 %p28};
//   %p29 = (241.6, 12);
//   %wire_37 = &"HAN" @WIRE(mode="straight") {%p28 %p29};
//   %wire_38 = &"HAN" @WIRE(mode="straight") {%p29 #"XSARA":27};
//   %wire_36 @TEXT("HAN", size=2.4, halign="middle", valign="baseline") => @PLACE(234.4, -12.8);
//   %wire_35 @TEXT("HAN", size=2.4, halign="middle", valign="baseline") => @PLACE(216.8, -12.8);
//   %p30 = (348.8, -124.5);
//   %wire_39 = &"BUSYB" @WIRE(mode="straight") {#"CPROBE7":1 %p30};
//   %p31 = (301.1, -84.8);
//   %wire_40 = &"BUSYB" @WIRE(mode="straight") {#"XSARB":1 %p31};
//   %wire_40 @TEXT("BUSYB", size=2.4, halign="start", valign="middle") => @PLACE(302.7, -84.8);
//   %wire_39 @TEXT("BUSYB", size=1.9, halign="start", valign="baseline") => @PLACE(349.4, -124);
//   %p32 = (326.4, -124.5);
//   %wire_41 = &"BUSYA" @WIRE(mode="straight") {#"CPROBE6":1 %p32};
//   %p33 = (301.1, 0);
//   %wire_42 = &"BUSYA" @WIRE(mode="straight") {#"XSARA":1 %p33};
//   %wire_42 @TEXT("BUSYA", size=2.4, halign="start", valign="middle") => @PLACE(302.7, 0);
//   %wire_41 @TEXT("BUSYA", size=1.9, halign="start", valign="baseline") => @PLACE(327, -124);
//   %p34 = (113.9, -40);
//   %wire_43 = {&"K_3" &"K_2" &"K_1" &"K_0"} @WIRE(mode="straight") {#"XDAC":18 %p34};
//   %p35 = (252.5, -80.8);
//   %wire_44 = {&"K_3" &"K_2" &"K_1" &"K_0"} @WIRE(mode="straight") {%p35 #"XSARB":3};
//   %p36 = (252.5, 4);
//   %wire_45 = {&"K_3" &"K_2" &"K_1" &"K_0"} @WIRE(mode="straight") {%p36 #"XSARA":3};
//   %wire_45 @TEXT("K<3:0>", size=2.4, halign="end", valign="middle") => @PLACE(250.9, 4);
//   %wire_44 @TEXT("K<3:0>", size=2.4, halign="end", valign="middle") => @PLACE(250.9, -80.8);
//   %wire_43 @TEXT("K<3:0>", size=2.4, halign="start", valign="middle") => @PLACE(115.5, -40);
//   %p37 = (301.1, -76.8);
//   %wire_46 = &"DB" @WIRE(mode="straight") {#"XSARB":2 %p37};
//   %p38 = (332.5, -24);
//   %wire_47 = &"DB" @WIRE(mode="straight") {%p38 #"XMERGE":28};
//   %p39 = (345.6, -196.8);
//   %wire_48 = &"DB" @WIRE(mode="straight") {%port_0:p %p39};
//   %wire_48 @TEXT("DB", size=1.9, halign="middle", valign="baseline") => @PLACE(343.6, -196.8);
//   %wire_47 @TEXT("DB", size=2.4, halign="end", valign="middle") => @PLACE(330.9, -24);
//   %wire_46 @TEXT("DB", size=2.4, halign="start", valign="middle") => @PLACE(302.7, -76.8);
//   %p40 = (301.1, 8);
//   %wire_49 = &"DA" @WIRE(mode="straight") {#"XSARA":2 %p40};
//   %p41 = (332.5, -8);
//   %wire_50 = &"DA" @WIRE(mode="straight") {%p41 #"XMERGE":27};
//   %p42 = (296.8, -196.8);
//   %wire_51 = &"DA" @WIRE(mode="straight") {%port_1:p %p42};
//   %wire_51 @TEXT("DA", size=1.9, halign="middle", valign="baseline") => @PLACE(294.8, -196.8);
//   %wire_50 @TEXT("DA", size=2.4, halign="end", valign="middle") => @PLACE(330.9, -8);
//   %wire_49 @TEXT("DA", size=2.4, halign="start", valign="middle") => @PLACE(302.7, 8);
//   %p43 = (40.3, -112);
//   %wire_52 = &"TB" @WIRE(mode="straight") {#"XCLK":5 %p43};
//   %p44 = (200, -87.7);
//   %wire_53 = &"TB" @WIRE(mode="straight") {#"S_BN":3 %p44};
//   %p45 = (200, -62.1);
//   %wire_54 = &"TB" @WIRE(mode="straight") {#"S_BP":3 %p45};
//   %p46 = (252.5, -76.8);
//   %wire_55 = &"TB" @WIRE(mode="straight") {%p46 #"XSARB":22};
//   %p47 = (248, -196.8);
//   %wire_56 = &"TB" @WIRE(mode="straight") {%port_2:p %p47};
//   %wire_56 @TEXT("TB", size=1.9, halign="middle", valign="baseline") => @PLACE(246, -196.8);
//   %wire_55 @TEXT("TB", size=2.4, halign="end", valign="middle") => @PLACE(250.9, -76.8);
//   %wire_54 @TEXT("TB", size=2.4, halign="start", valign="baseline") => @PLACE(200.6, -61.6);
//   %wire_53 @TEXT("TB", size=2.4, halign="start", valign="baseline") => @PLACE(200.6, -87.2);
//   %wire_52 @TEXT("TB", size=2.4, halign="start", valign="middle") => @PLACE(41.9, -112);
//   %p48 = (40.3, -108);
//   %wire_57 = &"TA" @WIRE(mode="straight") {#"XCLK":4 %p48};
//   %p49 = (200, -2.9);
//   %wire_58 = &"TA" @WIRE(mode="straight") {#"S_AN":3 %p49};
//   %p50 = (200, 22.7);
//   %wire_59 = &"TA" @WIRE(mode="straight") {#"S_AP":3 %p50};
//   %p51 = (252.5, 8);
//   %wire_60 = &"TA" @WIRE(mode="straight") {%p51 #"XSARA":22};
//   %p52 = (199.2, -196.8);
//   %wire_61 = &"TA" @WIRE(mode="straight") {%port_3:p %p52};
//   %wire_61 @TEXT("TA", size=1.9, halign="middle", valign="baseline") => @PLACE(197.2, -196.8);
//   %wire_60 @TEXT("TA", size=2.4, halign="end", valign="middle") => @PLACE(250.9, 8);
//   %wire_59 @TEXT("TA", size=2.4, halign="start", valign="baseline") => @PLACE(200.6, 23.2);
//   %wire_58 @TEXT("TA", size=2.4, halign="start", valign="baseline") => @PLACE(200.6, -2.4);
//   %wire_57 @TEXT("TA", size=2.4, halign="start", valign="middle") => @PLACE(41.9, -108);
//   %p53 = (132.5, -20);
//   %wire_62 = &"AMP" @WIRE(mode="straight") {%p53 #"XRA":1};
//   %p54 = (40.3, -100);
//   %wire_63 = &"AMP" @WIRE(mode="straight") {#"XCLK":2 %p54};
//   %p55 = (150.4, -196.8);
//   %wire_64 = &"AMP" @WIRE(mode="straight") {%port_4:p %p55};
//   %wire_64 @TEXT("AMP", size=1.9, halign="middle", valign="baseline") => @PLACE(148.4, -196.8);
//   %wire_63 @TEXT("AMP", size=2.4, halign="start", valign="middle") => @PLACE(41.9, -100);
//   %wire_62 @TEXT("AMP", size=2.4, halign="end", valign="middle") => @PLACE(130.9, -20);
//   %p56 = (387.5, -8);
//   %wire_65 = &"VALID" @WIRE(mode="straight") {#"XMERGE":43 %p56};
//   %p57 = (101.6, -187.2);
//   %wire_66 = &"VALID" @WIRE(mode="straight") {%port_10:p %p57};
//   %wire_66 @TEXT("VALID", size=1.9, halign="middle", valign="baseline") => @PLACE(99.6, -187.2);
//   %wire_65 @TEXT("VALID", size=2.4, halign="start", valign="middle") => @PLACE(389.1, -8);
//   %p58 = (316.8, 16);
//   %wire_67 = {&"QA_8" &"QA_7" &"QA_6" &"QA_5" &"QA_4" &"QA_3" &"QA_2" &"QA_1" &"QA_0"} @WIRE(mode="straight") {#"XSARA":12 %p58};
//   %p59 = (316.8, 0);
//   %wire_68 = {&"QA_8" &"QA_7" &"QA_6" &"QA_5" &"QA_4" &"QA_3" &"QA_2" &"QA_1" &"QA_0"} @WIRE(mode="straight") {%p59 %p58};
//   %wire_69 = {&"QA_8" &"QA_7" &"QA_6" &"QA_5" &"QA_4" &"QA_3" &"QA_2" &"QA_1" &"QA_0"} @WIRE(mode="straight") {%p59 #"XMERGE":1};
//   %wire_67 @TEXT("QA<8:0>", size=2.4, halign="middle", valign="baseline") => @PLACE(307.2, 16);
//   %p60 = (46.5, -6);
//   %wire_70 = {&"DP_14" &"DP_13" &"DP_12" &"DP_11" &"DP_10" &"DP_9" &"DP_8" &"DP_7" &"DP_6" &"DP_5" &"DP_4" &"DP_3" &"DP_2" &"DP_1" &"DP_0"} @WIRE(mode="straight") {#"XFLASH":35 %p60};
//   %p61 = (96, -124.5);
//   %wire_71 = {&"DP_14" &"DP_13" &"DP_12" &"DP_11" &"DP_10" &"DP_9" &"DP_8" &"DP_7" &"DP_6" &"DP_5" &"DP_4" &"DP_3" &"DP_2" &"DP_1" &"DP_0"} @WIRE(mode="straight") {%bundle_1:1 %p61};
//   %wire_71 @TEXT("DP<14:0>", size=2.4, halign="start", valign="baseline") => @PLACE(96.6, -124);
//   %wire_70 @TEXT("DP<14:0>", size=1.4, halign="start", valign="middle") => @PLACE(48.1, -6);
//   %p62 = (46.5, -4);
//   %wire_72 = {&"DN_14" &"DN_13" &"DN_12" &"DN_11" &"DN_10" &"DN_9" &"DN_8" &"DN_7" &"DN_6" &"DN_5" &"DN_4" &"DN_3" &"DN_2" &"DN_1" &"DN_0"} @WIRE(mode="straight") {#"XFLASH":20 %p62};
//   %p63 = (120, -124.5);
//   %wire_73 = {&"DN_14" &"DN_13" &"DN_12" &"DN_11" &"DN_10" &"DN_9" &"DN_8" &"DN_7" &"DN_6" &"DN_5" &"DN_4" &"DN_3" &"DN_2" &"DN_1" &"DN_0"} @WIRE(mode="straight") {%bundle_2:1 %p63};
//   %wire_73 @TEXT("DN<14:0>", size=2.4, halign="start", valign="baseline") => @PLACE(120.6, -124);
//   %wire_72 @TEXT("DN<14:0>", size=1.4, halign="start", valign="middle") => @PLACE(48.1, -4);
//   %p64 = (144, -137.5);
//   %wire_74 = &"VSS" @WIRE(mode="straight") {%p64 %bundle_3:2};
//   %wire_74 @TEXT("<*4>VSS", size=2.4, halign="start", valign="top") => @PLACE(144.6, -138);
//   %p65 = (120, -137.5);
//   %wire_75 = &"VSS" @WIRE(mode="straight") {%p65 %bundle_2:2};
//   %p66 = (96, -137.5);
//   %wire_76 = &"VSS" @WIRE(mode="straight") {%p66 %bundle_1:2};
//   %p67 = (72, -137.5);
//   %wire_77 = &"VSS" @WIRE(mode="straight") {%p67 %bundle_0:2};
//   %wire_77 @TEXT("<*15>VSS", size=2.4, halign="start", valign="top") => @PLACE(72.6, -138);
//   %wire_76 @TEXT("<*15>VSS", size=2.4, halign="start", valign="top") => @PLACE(96.6, -138);
//   %wire_75 @TEXT("<*15>VSS", size=2.4, halign="start", valign="top") => @PLACE(120.6, -138);
//   %p68 = (-3.5, -12);
//   %wire_78 = &"VCM" @WIRE(mode="straight") {%p68 #"XFLASH":60};
//   %p69 = (-3.5, -14);
//   %wire_79 = &"VCM" @WIRE(mode="straight") {%p69 #"XFLASH":75};
//   %wire_79 @TEXT("<*15>VCM", size=1.4, halign="end", valign="middle") => @PLACE(-5.1, -14);
//   %wire_78 @TEXT("<*15>VCM", size=1.4, halign="end", valign="middle") => @PLACE(-5.1, -12);
//   %p70 = (387.5, 0);
//   %wire_80 = {&"CODE_11" &"CODE_10" &"CODE_9" &"CODE_8" &"CODE_7" &"CODE_6" &"CODE_5" &"CODE_4" &"CODE_3" &"CODE_2" &"CODE_1" &"CODE_0"} @WIRE(mode="straight") {#"XMERGE":31 %p70};
//   %p71 = (52.8, -187.2);
//   %wire_81 = {&"CODE_11" &"CODE_10" &"CODE_9" &"CODE_8" &"CODE_7" &"CODE_6" &"CODE_5" &"CODE_4" &"CODE_3" &"CODE_2" &"CODE_1" &"CODE_0"} @WIRE(mode="straight") {%port_14:1 %p71};
//   %wire_81 @TEXT("CODE<11:0>", size=1.9, halign="middle", valign="baseline") => @PLACE(50.8, -187.2);
//   %wire_80 @TEXT("CODE<11:0>", size=2.4, halign="start", valign="middle") => @PLACE(389.1, 0);
//   %p72 = (132.5, -16);
//   %wire_82 = &"TRACK" @WIRE(mode="straight") {%p72 #"XRA":7};
//   %p73 = (40.3, -80);
//   %wire_83 = &"TRACK" @WIRE(mode="straight") {#"XCLK":1 %p73};
//   %p74 = (101.6, -196.8);
//   %wire_84 = &"TRACK" @WIRE(mode="straight") {%port_5:p %p74};
//   %wire_84 @TEXT("TRACK", size=1.9, halign="middle", valign="baseline") => @PLACE(99.6, -196.8);
//   %wire_83 @TEXT("TRACK", size=2.4, halign="start", valign="middle") => @PLACE(41.9, -80);
//   %wire_82 @TEXT("TRACK", size=2.4, halign="end", valign="middle") => @PLACE(130.9, -16);
//   %p75 = (387.5, -16);
//   %wire_85 = &"OVERFLOW" @WIRE(mode="straight") {#"XMERGE":45 %p75};
//   %p76 = (248, -187.2);
//   %wire_86 = &"OVERFLOW" @WIRE(mode="straight") {%port_13:p %p76};
//   %wire_86 @TEXT("OVERFLOW", size=1.9, halign="middle", valign="baseline") => @PLACE(246, -187.2);
//   %wire_85 @TEXT("OVERFLOW", size=2.4, halign="start", valign="middle") => @PLACE(389.1, -16);
//   %p77 = (387.5, -12);
//   %wire_87 = &"CHANNEL" @WIRE(mode="straight") {#"XMERGE":44 %p77};
//   %p78 = (199.2, -187.2);
//   %wire_88 = &"CHANNEL" @WIRE(mode="straight") {%port_12:p %p78};
//   %wire_88 @TEXT("CHANNEL", size=1.9, halign="middle", valign="baseline") => @PLACE(197.2, -187.2);
//   %wire_87 @TEXT("CHANNEL", size=2.4, halign="start", valign="middle") => @PLACE(389.1, -12);
//   %p79 = (387.5, -4);
//   %wire_89 = &"RECON" @WIRE(mode="straight") {#"XMERGE":46 %p79};
//   %p80 = (150.4, -187.2);
//   %wire_90 = &"RECON" @WIRE(mode="straight") {%port_11:p %p80};
//   %wire_90 @TEXT("RECON", size=1.9, halign="middle", valign="baseline") => @PLACE(148.4, -187.2);
//   %wire_89 @TEXT("RECON", size=2.4, halign="start", valign="middle") => @PLACE(389.1, -4);
//   %p81 = (46.5, 0);
//   %wire_91 = {&"BIN_3" &"BIN_2" &"BIN_1" &"BIN_0"} @WIRE(mode="straight") {#"XFLASH":1 %p81};
//   %p82 = (144, -124.5);
//   %wire_92 = {&"BIN_3" &"BIN_2" &"BIN_1" &"BIN_0"} @WIRE(mode="straight") {%bundle_3:1 %p82};
//   %p83 = (52.8, -196.8);
//   %wire_93 = {&"BIN_3" &"BIN_2" &"BIN_1" &"BIN_0"} @WIRE(mode="straight") {%port_6:1 %p83};
//   %wire_93 @TEXT("BIN<3:0>", size=1.9, halign="middle", valign="baseline") => @PLACE(50.8, -196.8);
//   %wire_92 @TEXT("BIN<3:0>", size=2.4, halign="start", valign="baseline") => @PLACE(144.6, -124);
//   %wire_91 @TEXT("BIN<3:0>", size=1.4, halign="start", valign="middle") => @PLACE(48.1, 0);
//   %p84 = (57.5, -2);
//   %wire_94 = {&"D_14" &"D_13" &"D_12" &"D_11" &"D_10" &"D_9" &"D_8" &"D_7" &"D_6" &"D_5" &"D_4" &"D_3" &"D_2" &"D_1" &"D_0"} @WIRE(mode="straight") {#"XFLASH":5 %p84};
//   %p85 = (57.5, -32);
//   %wire_95 = {&"D_14" &"D_13" &"D_12" &"D_11" &"D_10" &"D_9" &"D_8" &"D_7" &"D_6" &"D_5" &"D_4" &"D_3" &"D_2" &"D_1" &"D_0"} @WIRE(mode="straight") {%p85 %p84};
//   %wire_96 = {&"D_14" &"D_13" &"D_12" &"D_11" &"D_10" &"D_9" &"D_8" &"D_7" &"D_6" &"D_5" &"D_4" &"D_3" &"D_2" &"D_1" &"D_0"} @WIRE(mode="straight") {%p85 #"XDAC":1};
//   %p86 = (72, -124.5);
//   %wire_97 = {&"D_14" &"D_13" &"D_12" &"D_11" &"D_10" &"D_9" &"D_8" &"D_7" &"D_6" &"D_5" &"D_4" &"D_3" &"D_2" &"D_1" &"D_0"} @WIRE(mode="straight") {%bundle_0:1 %p86};
//   %p87 = (4, -196.8);
//   %wire_98 = {&"D_14" &"D_13" &"D_12" &"D_11" &"D_10" &"D_9" &"D_8" &"D_7" &"D_6" &"D_5" &"D_4" &"D_3" &"D_2" &"D_1" &"D_0"} @WIRE(mode="straight") {%port_7:1 %p87};
//   %wire_98 @TEXT("D<14:0>", size=1.9, halign="middle", valign="baseline") => @PLACE(2, -196.8);
//   %wire_97 @TEXT("D<14:0>", size=2.4, halign="start", valign="baseline") => @PLACE(72.6, -124);
//   %wire_94 @TEXT("D<14:0>", size=2.4, halign="middle", valign="baseline") => @PLACE(50.3, -2);
//   %p88 = (184.8, -4);
//   %wire_99 = &"RON" @WIRE(mode="straight") {#"XRA":5 %p88};
//   %p89 = (184.8, -12.8);
//   %wire_100 = &"RON" @WIRE(mode="straight") {%p89 %p88};
//   %wire_101 = &"RON" @WIRE(mode="straight") {%p89 #"S_AN":1};
//   %p90 = (190.1, -97.6);
//   %wire_102 = &"RON" @WIRE(mode="straight") {%p90 #"S_BN":1};
//   %p91 = (345.6, -187.2);
//   %wire_103 = &"RON" @WIRE(mode="straight") {%port_8:p %p91};
//   %wire_103 @TEXT("RON", size=1.9, halign="middle", valign="baseline") => @PLACE(343.6, -187.2);
//   %wire_102 @TEXT("RON", size=2.4, halign="end", valign="middle") => @PLACE(188.5, -97.6);
//   %wire_99 @TEXT("RON", size=2.4, halign="middle", valign="baseline") => @PLACE(180.4, -4);
//   %p92 = (184.8, 0);
//   %wire_104 = &"ROP" @WIRE(mode="straight") {#"XRA":6 %p92};
//   %p93 = (184.8, 12.8);
//   %wire_105 = &"ROP" @WIRE(mode="straight") {%p92 %p93};
//   %wire_106 = &"ROP" @WIRE(mode="straight") {%p93 #"S_AP":1};
//   %p94 = (190.1, -72);
//   %wire_107 = &"ROP" @WIRE(mode="straight") {%p94 #"S_BP":1};
//   %p95 = (296.8, -187.2);
//   %wire_108 = &"ROP" @WIRE(mode="straight") {%port_9:p %p95};
//   %wire_108 @TEXT("ROP", size=1.9, halign="middle", valign="baseline") => @PLACE(294.8, -187.2);
//   %wire_107 @TEXT("ROP", size=2.4, halign="end", valign="middle") => @PLACE(188.5, -72);
//   %wire_104 @TEXT("ROP", size=2.4, halign="middle", valign="baseline") => @PLACE(180.4, 0);
//   %p96 = (301.1, 12);
//   %wire_109 = {&"KA_3" &"KA_2" &"KA_1" &"KA_0"} @WIRE(mode="straight") {#"XSARA":7 %p96};
//   %p97 = (332.5, -4);
//   %wire_110 = {&"KA_3" &"KA_2" &"KA_1" &"KA_0"} @WIRE(mode="straight") {%p97 #"XMERGE":19};
//   %wire_110 @TEXT("KA<3:0>", size=2.4, halign="end", valign="middle") => @PLACE(330.9, -4);
//   %wire_109 @TEXT("KA<3:0>", size=2.4, halign="start", valign="middle") => @PLACE(302.7, 12);
//   %p98 = (132.5, -24);
//   %wire_111 = &"RESET" @WIRE(mode="straight") {%p98 #"XRA":4};
//   %p99 = (40.3, -104);
//   %wire_112 = &"RESET" @WIRE(mode="straight") {#"XCLK":3 %p99};
//   %wire_112 @TEXT("RESET", size=2.4, halign="start", valign="middle") => @PLACE(41.9, -104);
//   %wire_111 @TEXT("RESET", size=2.4, halign="end", valign="middle") => @PLACE(130.9, -24);
//   %p100 = (301.1, -80.8);
//   %wire_113 = &"OFB" @WIRE(mode="straight") {#"XSARB":11 %p100};
//   %p101 = (332.5, -28);
//   %wire_114 = &"OFB" @WIRE(mode="straight") {%p101 #"XMERGE":30};
//   %wire_114 @TEXT("OFB", size=2.4, halign="end", valign="middle") => @PLACE(330.9, -28);
//   %wire_113 @TEXT("OFB", size=2.4, halign="start", valign="middle") => @PLACE(302.7, -80.8);
//   %p102 = (301.1, 4);
//   %wire_115 = &"OFA" @WIRE(mode="straight") {#"XSARA":11 %p102};
//   %p103 = (332.5, -12);
//   %wire_116 = &"OFA" @WIRE(mode="straight") {%p103 #"XMERGE":29};
//   %wire_116 @TEXT("OFA", size=2.4, halign="end", valign="middle") => @PLACE(330.9, -12);
//   %wire_115 @TEXT("OFA", size=2.4, halign="start", valign="middle") => @PLACE(302.7, 4);
//   %p104 = (119.2, -32);
//   %wire_117 = &"DACP" @WIRE(mode="straight") {#"XDAC":16 %p104};
//   %p105 = (119.2, -8);
//   %wire_118 = &"DACP" @WIRE(mode="straight") {%p104 %p105};
//   %wire_119 = &"DACP" @WIRE(mode="straight") {%p105 #"XRA":3};
//   %wire_117 @TEXT("DACP", size=2.4, halign="middle", valign="baseline") => @PLACE(114.8, -32);
//   %p106 = (125.6, -36);
//   %wire_120 = &"DACN" @WIRE(mode="straight") {#"XDAC":17 %p106};
//   %p107 = (125.6, -12);
//   %wire_121 = &"DACN" @WIRE(mode="straight") {%p106 %p107};
//   %wire_122 = &"DACN" @WIRE(mode="straight") {%p107 #"XRA":2};
//   %wire_120 @TEXT("DACN", size=2.4, halign="middle", valign="baseline") => @PLACE(118, -36);
//   %p108 = (301.1, -72.8);
//   %wire_123 = {&"KB_3" &"KB_2" &"KB_1" &"KB_0"} @WIRE(mode="straight") {#"XSARB":7 %p108};
//   %p109 = (332.5, -20);
//   %wire_124 = {&"KB_3" &"KB_2" &"KB_1" &"KB_0"} @WIRE(mode="straight") {%p109 #"XMERGE":23};
//   %wire_124 @TEXT("KB<3:0>", size=2.4, halign="end", valign="middle") => @PLACE(330.9, -20);
//   %wire_123 @TEXT("KB<3:0>", size=2.4, halign="start", valign="middle") => @PLACE(302.7, -72.8);
//   %p110 = (26, 12.5);
//   %wire_125 = &"IB_B" @WIRE(mode="straight") {#"XFLASH":51 %p110};
//   %p111 = (4, -187.2);
//   %wire_126 = &"IB_B" @WIRE(mode="straight") {%port_15:p %p111};
//   %wire_126 @TEXT("IB\_B", size=1.9, halign="middle", valign="baseline") => @PLACE(2, -187.2);
//   %wire_125 @TEXT("IB\_B", size=1.4, halign="start", valign="middle", rotate=90) => @PLACE(26.6, 13);
//   %p112 = (28, 12.5);
//   %wire_127 = &"IB_A" @WIRE(mode="straight") {#"XFLASH":50 %p112};
//   %p113 = (345.6, -177.6);
//   %wire_128 = &"IB_A" @WIRE(mode="straight") {%port_16:p %p113};
//   %wire_128 @TEXT("IB\_A", size=1.9, halign="middle", valign="baseline") => @PLACE(343.6, -177.6);
//   %wire_127 @TEXT("IB\_A", size=1.4, halign="start", valign="middle", rotate=90) => @PLACE(28.6, 13);
//   %p114 = (20, 12.5);
//   %wire_129 = &"VREFN" @WIRE(mode="straight") {#"XFLASH":90 %p114};
//   %p115 = (68.5, -40);
//   %wire_130 = &"VREFN" @WIRE(mode="straight") {%p115 #"XDAC":24};
//   %p116 = (252.8, -16);
//   %wire_131 = &"VREFN" @WIRE(mode="straight") {%p116 #"XSARA":29};
//   %p117 = (296.8, -177.6);
//   %wire_132 = &"VREFN" @WIRE(mode="straight") {%port_17:p %p117};
//   %p118 = (252.8, -100.8);
//   %wire_133 = &"VREFN" @WIRE(mode="straight") {%p118 #"XSARB":29};
//   %wire_133 @TEXT("VREFN", size=1.6, halign="middle", valign="baseline") => @PLACE(254.4, -100.8);
//   %wire_132 @TEXT("VREFN", size=1.9, halign="middle", valign="baseline") => @PLACE(294.8, -177.6);
//   %wire_131 @TEXT("VREFN", size=1.6, halign="middle", valign="baseline") => @PLACE(254.4, -16);
//   %wire_130 @TEXT("VREFN", size=2.4, halign="end", valign="middle") => @PLACE(66.9, -40);
//   %wire_129 @TEXT("VREFN", size=1.4, halign="start", valign="middle", rotate=90) => @PLACE(20.6, 13);
//   %p119 = (18, 12.5);
//   %wire_134 = &"VREFP" @WIRE(mode="straight") {#"XFLASH":91 %p119};
//   %p120 = (68.5, -36);
//   %wire_135 = &"VREFP" @WIRE(mode="straight") {%p120 #"XDAC":23};
//   %p121 = (252.8, -12);
//   %wire_136 = &"VREFP" @WIRE(mode="straight") {%p121 #"XSARA":30};
//   %p122 = (248, -177.6);
//   %wire_137 = &"VREFP" @WIRE(mode="straight") {%port_18:p %p122};
//   %p123 = (252.8, -96.8);
//   %wire_138 = &"VREFP" @WIRE(mode="straight") {%p123 #"XSARB":30};
//   %wire_138 @TEXT("VREFP", size=1.6, halign="middle", valign="baseline") => @PLACE(254.4, -96.8);
//   %wire_137 @TEXT("VREFP", size=1.9, halign="middle", valign="baseline") => @PLACE(246, -177.6);
//   %wire_136 @TEXT("VREFP", size=1.6, halign="middle", valign="baseline") => @PLACE(254.4, -12);
//   %wire_135 @TEXT("VREFP", size=2.4, halign="end", valign="middle") => @PLACE(66.9, -36);
//   %wire_134 @TEXT("VREFP", size=1.4, halign="start", valign="middle", rotate=90) => @PLACE(18.6, 13);
//   %p124 = (24, 12.5);
//   %wire_139 = &"VCM" @WIRE(mode="straight") {#"XFLASH":56 %p124};
//   %p125 = (68.5, -44);
//   %wire_140 = &"VCM" @WIRE(mode="straight") {%p125 #"XDAC":22};
//   %p126 = (132.5, -28);
//   %wire_141 = &"VCM" @WIRE(mode="straight") {%p126 #"XRA":8};
//   %p127 = (252.8, -92.8);
//   %wire_142 = &"VCM" @WIRE(mode="straight") {%p127 #"XSARB":23};
//   %p128 = (252.8, -8);
//   %wire_143 = &"VCM" @WIRE(mode="straight") {%p128 #"XSARA":23};
//   %p129 = (227.2, -107.1);
//   %wire_144 = &"VCM" @WIRE(mode="straight") {%p129 #"CH_BN":2};
//   %p130 = (227.2, -81.5);
//   %wire_145 = &"VCM" @WIRE(mode="straight") {%p130 #"CH_BP":2};
//   %p131 = (227.2, -22.3);
//   %wire_146 = &"VCM" @WIRE(mode="straight") {%p131 #"CH_AN":2};
//   %p132 = (227.2, 3.3);
//   %wire_147 = &"VCM" @WIRE(mode="straight") {%p132 #"CH_AP":2};
//   %p133 = (199.2, -177.6);
//   %wire_148 = &"VCM" @WIRE(mode="straight") {%port_19:p %p133};
//   %wire_148 @TEXT("VCM", size=1.9, halign="middle", valign="baseline") => @PLACE(197.2, -177.6);
//   %wire_147 @TEXT("VCM", size=2.4, halign="start", valign="top") => @PLACE(227.8, 2.8);
//   %wire_146 @TEXT("VCM", size=2.4, halign="start", valign="top") => @PLACE(227.8, -22.8);
//   %wire_145 @TEXT("VCM", size=2.4, halign="start", valign="top") => @PLACE(227.8, -82);
//   %wire_144 @TEXT("VCM", size=2.4, halign="start", valign="top") => @PLACE(227.8, -107.6);
//   %wire_143 @TEXT("VCM", size=1.6, halign="middle", valign="baseline") => @PLACE(254.4, -8);
//   %wire_141 @TEXT("VCM", size=2.4, halign="end", valign="middle") => @PLACE(130.9, -28);
//   %wire_140 @TEXT("VCM", size=2.4, halign="end", valign="middle") => @PLACE(66.9, -44);
//   %wire_139 @TEXT("VCM", size=1.4, halign="start", valign="middle", rotate=90) => @PLACE(24.6, 13);
//   %wire_142 @TEXT("VCM", size=1.6, halign="middle", valign="baseline") => @PLACE(254.4, -92.8);
//   %p134 = (16, 12.5);
//   %wire_149 = &"VSS" @WIRE(mode="straight") {#"XFLASH":92 %p134};
//   %p135 = (68.5, -52);
//   %wire_150 = &"VSS" @WIRE(mode="straight") {%p135 #"XDAC":26};
//   %p136 = (132.5, -36);
//   %wire_151 = &"VSS" @WIRE(mode="straight") {%p136 #"XRA":12};
//   %p137 = (-3.5, -84);
//   %wire_152 = &"VSS" @WIRE(mode="straight") {%p137 #"XCLK":11};
//   %p138 = (348.8, -137.5);
//   %wire_153 = &"VSS" @WIRE(mode="straight") {%p138 #"CPROBE7":2};
//   %p139 = (326.4, -137.5);
//   %wire_154 = &"VSS" @WIRE(mode="straight") {%p139 #"CPROBE6":2};
//   %p140 = (304, -137.5);
//   %wire_155 = &"VSS" @WIRE(mode="straight") {%p140 #"CPROBE5":2};
//   %p141 = (259.2, -137.5);
//   %wire_156 = &"VSS" @WIRE(mode="straight") {%p141 #"CPROBE3":2};
//   %p142 = (281.6, -137.5);
//   %wire_157 = &"VSS" @WIRE(mode="straight") {%p142 #"CPROBE4":2};
//   %p143 = (236.8, -137.5);
//   %wire_158 = &"VSS" @WIRE(mode="straight") {%p143 #"CPROBE2":2};
//   %p144 = (214.4, -137.5);
//   %wire_159 = &"VSS" @WIRE(mode="straight") {%p144 #"CPROBE1":2};
//   %p145 = (192, -137.5);
//   %wire_160 = &"VSS" @WIRE(mode="straight") {%p145 #"CPROBE0":2};
//   %p146 = (252.5, -88.8);
//   %wire_161 = &"VSS" @WIRE(mode="straight") {%p146 #"XSARB":31};
//   %p147 = (252.5, -4);
//   %wire_162 = &"VSS" @WIRE(mode="straight") {%p147 #"XSARA":31};
//   %p148 = (332.5, -36);
//   %wire_163 = &"VSS" @WIRE(mode="straight") {%p148 #"XMERGE":48};
//   %p149 = (150.4, -177.6);
//   %wire_164 = &"VSS" @WIRE(mode="straight") {%port_20:p %p149};
//   %wire_164 @TEXT("VSS", size=1.9, halign="middle", valign="baseline") => @PLACE(148.4, -177.6);
//   %wire_163 @TEXT("VSS", size=2.4, halign="end", valign="middle") => @PLACE(330.9, -36);
//   %wire_162 @TEXT("VSS", size=2.4, halign="end", valign="middle") => @PLACE(250.9, -4);
//   %wire_161 @TEXT("VSS", size=2.4, halign="end", valign="middle") => @PLACE(250.9, -88.8);
//   %wire_160 @TEXT("VSS", size=1.9, halign="start", valign="top") => @PLACE(192.6, -138);
//   %wire_159 @TEXT("VSS", size=1.9, halign="start", valign="top") => @PLACE(215, -138);
//   %wire_158 @TEXT("VSS", size=1.9, halign="start", valign="top") => @PLACE(237.4, -138);
//   %wire_156 @TEXT("VSS", size=1.9, halign="start", valign="top") => @PLACE(259.8, -138);
//   %wire_157 @TEXT("VSS", size=1.9, halign="start", valign="top") => @PLACE(282.2, -138);
//   %wire_155 @TEXT("VSS", size=1.9, halign="start", valign="top") => @PLACE(304.6, -138);
//   %wire_154 @TEXT("VSS", size=1.9, halign="start", valign="top") => @PLACE(327, -138);
//   %wire_153 @TEXT("VSS", size=1.9, halign="start", valign="top") => @PLACE(349.4, -138);
//   %wire_152 @TEXT("VSS", size=2.4, halign="end", valign="middle") => @PLACE(-5.1, -84);
//   %wire_151 @TEXT("VSS", size=2.4, halign="end", valign="middle") => @PLACE(130.9, -36);
//   %wire_150 @TEXT("VSS", size=2.4, halign="end", valign="middle") => @PLACE(66.9, -52);
//   %wire_149 @TEXT("VSS", size=1.4, halign="start", valign="middle", rotate=90) => @PLACE(16.6, 13);
//   %p150 = (22, 12.5);
//   %wire_165 = &"VDD" @WIRE(mode="straight") {#"XFLASH":57 %p150};
//   %p151 = (68.5, -48);
//   %wire_166 = &"VDD" @WIRE(mode="straight") {%p151 #"XDAC":25};
//   %p152 = (132.5, -32);
//   %wire_167 = &"VDD" @WIRE(mode="straight") {%p152 #"XRA":9};
//   %p153 = (-3.5, -80);
//   %wire_168 = &"VDD" @WIRE(mode="straight") {%p153 #"XCLK":10};
//   %p154 = (252.5, -84.8);
//   %wire_169 = &"VDD" @WIRE(mode="straight") {%p154 #"XSARB":25};
//   %p155 = (252.5, 0);
//   %wire_170 = &"VDD" @WIRE(mode="straight") {%p155 #"XSARA":25};
//   %p156 = (332.5, -32);
//   %wire_171 = &"VDD" @WIRE(mode="straight") {%p156 #"XMERGE":47};
//   %p157 = (101.6, -177.6);
//   %wire_172 = &"VDD" @WIRE(mode="straight") {%port_21:p %p157};
//   %wire_172 @TEXT("VDD", size=1.9, halign="middle", valign="baseline") => @PLACE(99.6, -177.6);
//   %wire_171 @TEXT("VDD", size=2.4, halign="end", valign="middle") => @PLACE(330.9, -32);
//   %wire_170 @TEXT("VDD", size=2.4, halign="end", valign="middle") => @PLACE(250.9, 0);
//   %wire_169 @TEXT("VDD", size=2.4, halign="end", valign="middle") => @PLACE(250.9, -84.8);
//   %wire_168 @TEXT("VDD", size=2.4, halign="end", valign="middle") => @PLACE(-5.1, -80);
//   %wire_167 @TEXT("VDD", size=2.4, halign="end", valign="middle") => @PLACE(130.9, -32);
//   %wire_166 @TEXT("VDD", size=2.4, halign="end", valign="middle") => @PLACE(66.9, -48);
//   %wire_165 @TEXT("VDD", size=1.4, halign="start", valign="middle", rotate=90) => @PLACE(22.6, 13);
//   %p158 = (-3.5, -8);
//   %wire_173 = &"VINN" @WIRE(mode="straight") {%p158 #"XFLASH":58};
//   %p159 = (132.5, -4);
//   %wire_174 = &"VINN" @WIRE(mode="straight") {%p159 #"XRA":10};
//   %p160 = (52.8, -177.6);
//   %wire_175 = &"VINN" @WIRE(mode="straight") {%port_22:p %p160};
//   %wire_175 @TEXT("VINN", size=1.9, halign="middle", valign="baseline") => @PLACE(50.8, -177.6);
//   %wire_174 @TEXT("VINN", size=2.4, halign="end", valign="middle") => @PLACE(130.9, -4);
//   %wire_173 @TEXT("VINN", size=1.4, halign="end", valign="middle") => @PLACE(-5.1, -8);
//   %p161 = (-3.5, -10);
//   %wire_176 = &"VINP" @WIRE(mode="straight") {%p161 #"XFLASH":59};
//   %p162 = (132.5, 0);
//   %wire_177 = &"VINP" @WIRE(mode="straight") {%p162 #"XRA":11};
//   %p163 = (4, -177.6);
//   %wire_178 = &"VINP" @WIRE(mode="straight") {%port_23:p %p163};
//   %wire_178 @TEXT("VINP", size=1.9, halign="middle", valign="baseline") => @PLACE(2, -177.6);
//   %wire_177 @TEXT("VINP", size=2.4, halign="end", valign="middle") => @PLACE(130.9, 0);
//   %wire_176 @TEXT("VINP", size=1.4, halign="end", valign="middle") => @PLACE(-5.1, -10);
//   (0, -277.3) @TEXT("Pre-layout candidate: no extracted views; transient noise and mismatch disabled.", size=2.7, halign="start", valign="baseline");
//   (0, -271.4) @TEXT("External Switch+Cs2 hold remains; real SAR CDAC adds actual loading.", size=2.7, halign="start", valign="baseline");
//   (0, -265.4) @TEXT("Merge C12=256*K4+Q9-128. Vrecon=(C12+0.5)/2048-1.", size=2.7, halign="start", valign="baseline");
//   (0, -259.5) @TEXT("Q commit at nT+2.390ns; DA/DB at2.410ns. Read final code at nT+2.450ns.", size=2.7, halign="start", valign="baseline");
//   (0, -253.6) @TEXT("Backend CLKA 500..990ps; CLKAE ends970ps; CLKB starts1010ps.", size=2.7, halign="start", valign="baseline");
//   (0, -247.7) @TEXT("SAR A samples even cycles; B odd cycles. Raw EOC -> weighted decode -> fixed commit.", size=2.7, halign="start", valign="baseline");
//   (0, -241.8) @TEXT("0..250ps sample | 250..500ps Flash | 500..1000ps amplify.", size=2.7, halign="start", valign="baseline");
//   (0, -235.8) @TEXT("Each lane repeats at500MS/s. Source nonbinary10-decision SAR with actual EOC.", size=2.7, halign="start", valign="baseline");
//   (0, 42.1) @TEXT("VDD=1V; VCM=0.5V; quantizer FSdiff=2Vpp; nominal settled ROP/RON=0.25..0.75V.", size=2.7, halign="start", valign="baseline");
//   (0, 48) @TEXT("1GS/s / real4b Flash + SC MDAC G8 (ideal OTA) + 2 real9b SAR lanes", size=2.7, halign="start", valign="baseline")
// }
ends PIPE_TOP_F4_TI2_RS9
