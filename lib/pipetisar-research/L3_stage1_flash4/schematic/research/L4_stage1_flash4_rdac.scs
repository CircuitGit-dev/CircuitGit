// @RNL(type="header") {
// @VERSION("0.3");
// @USE-PACKAGE(name="rnl-std-spectre", version="0.3", path="rnl-std-spectre.rnl");
// @USE-PACKAGE(name="eda-symbol", version="0.1", path="eda-symbol.rnl");
// @USE-PACKAGE(name="eda-style", version="0.1", path="eda-style.rnl")
// }
// Design: 2026_PIPETISAR_RESEARCH/L4_stage1_flash4_rdac
simulator lang=spectre
global 0

// 2026_PIPETISAR_RESEARCH/L4_stage1_flash4_rdac/schematic
//Series configuration of R15
subckt L4_stage1_flash4_rdac VREF_14 VREF_13 VREF_12 VREF_11 VREF_10 VREF_9 VREF_8 VREF_7 VREF_6 VREF_5 VREF_4 VREF_3 VREF_2 VREF_1 VREF_0 VREFN VREFP
//Series configuration of R15
R15 (VREF_14 R15_1__dmy0 ) rnods l=1.5u w=1u m=1 multi=(1)
R15_2__dmy0 (R15_1__dmy0 R15_2__dmy0 ) rnods l=1.5u w=1u m=1 multi=(1)
R15_3__dmy0 (R15_2__dmy0 R15_3__dmy0 ) rnods l=1.5u w=1u m=1 multi=(1)
R15_4__dmy0 (R15_3__dmy0 R15_4__dmy0 ) rnods l=1.5u w=1u m=1 multi=(1)
R15_5__dmy0 (R15_4__dmy0 R15_5__dmy0 ) rnods l=1.5u w=1u m=1 multi=(1)
R15_6__dmy0 (R15_5__dmy0 R15_6__dmy0 ) rnods l=1.5u w=1u m=1 multi=(1)
R15_7__dmy0 (R15_6__dmy0 R15_7__dmy0 ) rnods l=1.5u w=1u m=1 multi=(1)
R15_8__dmy0 (R15_7__dmy0 R15_8__dmy0 ) rnods l=1.5u w=1u m=1 multi=(1)
R15_9__dmy0 (R15_8__dmy0 VREFP ) rnods l=1.5u w=1u m=1 multi=(1)
//End of R15

R14 (VREF_13 VREF_14 ) rnods l=1.5u w=1u m=1 multi=(1)

R13 (VREF_12 VREF_13 ) rnods l=1.5u w=1u m=1 multi=(1)

R12 (VREF_11 VREF_12 ) rnods l=1.5u w=1u m=1 multi=(1)

R11 (VREF_10 VREF_11 ) rnods l=1.5u w=1u m=1 multi=(1)

R10 (VREF_9 VREF_10 ) rnods l=1.5u w=1u m=1 multi=(1)

R9 (VREF_8 VREF_9 ) rnods l=1.5u w=1u m=1 multi=(1)

R8 (VREF_7 VREF_8 ) rnods l=1.5u w=1u m=1 multi=(1)

R7 (VREF_6 VREF_7 ) rnods l=1.5u w=1u m=1 multi=(1)

R6 (VREF_5 VREF_6 ) rnods l=1.5u w=1u m=1 multi=(1)

R5 (VREF_4 VREF_5 ) rnods l=1.5u w=1u m=1 multi=(1)

R4 (VREF_3 VREF_4 ) rnods l=1.5u w=1u m=1 multi=(1)

R3 (VREF_2 VREF_3 ) rnods l=1.5u w=1u m=1 multi=(1)

R2 (VREF_1 VREF_2 ) rnods l=1.5u w=1u m=1 multi=(1)

R1 (VREF_0 VREF_1 ) rnods l=1.5u w=1u m=1 multi=(1)

//Series configuration of R0
R0 (VREFN R0_1__dmy0 ) rnods l=1.5u w=1u m=1 multi=(1)
R0_2__dmy0 (R0_1__dmy0 R0_2__dmy0 ) rnods l=1.5u w=1u m=1 multi=(1)
R0_3__dmy0 (R0_2__dmy0 R0_3__dmy0 ) rnods l=1.5u w=1u m=1 multi=(1)
R0_4__dmy0 (R0_3__dmy0 R0_4__dmy0 ) rnods l=1.5u w=1u m=1 multi=(1)
R0_5__dmy0 (R0_4__dmy0 R0_5__dmy0 ) rnods l=1.5u w=1u m=1 multi=(1)
R0_6__dmy0 (R0_5__dmy0 R0_6__dmy0 ) rnods l=1.5u w=1u m=1 multi=(1)
R0_7__dmy0 (R0_6__dmy0 R0_7__dmy0 ) rnods l=1.5u w=1u m=1 multi=(1)
R0_8__dmy0 (R0_7__dmy0 R0_8__dmy0 ) rnods l=1.5u w=1u m=1 multi=(1)
R0_9__dmy0 (R0_8__dmy0 VREF_0 ) rnods l=1.5u w=1u m=1 multi=(1)
//End of R0

// @RNL(author="rnl-virtuoso") {
// %block_symbol = @DEFINE-SYMBOL(box=[-10, -14, 17, 0]) {
// @LINE {(17, -9) (13, -9)};
// @LINE {(0, 0) (0, -4)};
// @LINE {(2, 0) (2, -4)};
// @RECTANGLE {(-10, -14) (13, -4)};
// ? @TEXT("${name}", size=1, halign="start", valign="middle", key="name") => @PLACE(13, -4);
// ? @TEXT("${model}", size=1, halign="middle", valign="middle", key="model") => @PLACE(1.5, -9);
// (17, -9) @PIN(terminal=["VREF_14", "VREF_13", "VREF_12", "VREF_11", "VREF_10", "VREF_9", "VREF_8", "VREF_7", "VREF_6", "VREF_5", "VREF_4", "VREF_3", "VREF_2", "VREF_1", "VREF_0"]);
// (12.4, -9) @TEXT("VREF<14:0>", size=1, halign="end", valign="middle");
// (0, 0) @PIN(terminal="VREFP");
// (0, -4.6) @TEXT("VREFP", size=1, halign="end", valign="middle", rotate=90);
// (2, 0) @PIN(terminal="VREFN");
// (2, -4.6) @TEXT("VREFN", size=1, halign="end", valign="middle", rotate=90)
// };
// # @SET-SYMBOL %block_symbol;
// %symbol_0 = @DEFINE-SYMBOL(box=[-2, -6, 2, 0]) {
// @LINE {(0, -6) (0, -4.8) (-1, -4.5) (1, -3.9) (-1, -3.3) (1, -2.7) (-1, -2.1) (1, -1.5) (0, -1.2) (0, 0)};
// ? @TEXT("${name}", size=0.8, halign="start", valign="baseline", key="name") => @PLACE(1.4, 0.5);
// ? @TEXT("${model}", size=0.8, halign="end", valign="baseline", key="model") => @PLACE(-1, 0.3);
// (0, -6) @PIN(terminal=2);
// (0, 0) @PIN(terminal=1)
// };
// #"R10" @SET-SYMBOL %symbol_0;
// #"R10" @PLACE(0, -240) => @ORIENT("R0");
// %expanded_type_2 = @DEFINE(roles=["{parts}", ["p1", "terminal"], ["p2", "terminal"]]) {};
// %expanded_members_symbol = @DEFINE-SYMBOL {};
// {#"R15" #"R15_2__dmy0" #"R15_3__dmy0" #"R15_4__dmy0" #"R15_5__dmy0" #"R15_6__dmy0" #"R15_7__dmy0" #"R15_8__dmy0" #"R15_9__dmy0"} @SET-SYMBOL %expanded_members_symbol;
// {#"R15" #"R15_2__dmy0" #"R15_3__dmy0" #"R15_4__dmy0" #"R15_5__dmy0" #"R15_6__dmy0" #"R15_7__dmy0" #"R15_8__dmy0" #"R15_9__dmy0"} @PLACE(0, -360);
// %expanded_0 = {#"R15" #"R15_2__dmy0" #"R15_3__dmy0" #"R15_4__dmy0" #"R15_5__dmy0" #"R15_6__dmy0" #"R15_7__dmy0" #"R15_8__dmy0" #"R15_9__dmy0"}(parts) #"R15":1(p1) #"R15_9__dmy0":2(p2) @AS %expanded_type_2;
// %symbol_1 = @DEFINE-SYMBOL(box=[-2, -6, 2, 0]) {
// @LINE {(0, -6) (0, -4.8) (-1, -4.5) (1, -3.9) (-1, -3.3) (1, -2.7) (-1, -2.1) (1, -1.5) (0, -1.2) (0, 0)};
// ? @TEXT("${name}", size=0.8, halign="start", valign="baseline", key="name") => @PLACE(1.4, 0.5);
// ? @TEXT("${model}", size=0.8, halign="end", valign="baseline", key="model") => @PLACE(-1, 0.3);
// (0, -6) @PIN(terminal="p2");
// (0, 0) @PIN(terminal="p1")
// };
// %expanded_0 @SET-SYMBOL %symbol_1;
// %expanded_0 @PLACE(0, -360) => @ORIENT("R90");
// %expanded_0 @TEXT("R15", key="name");
// %expanded_0 @TEXT("rnods", key="model");
// #"R6" @SET-SYMBOL %symbol_0;
// #"R6" @PLACE(0, -144) => @ORIENT("R0");
// #"R13" @SET-SYMBOL %symbol_0;
// #"R13" @PLACE(0, -312) => @ORIENT("R0");
// #"R8" @SET-SYMBOL %symbol_0;
// #"R8" @PLACE(0, -192) => @ORIENT("R0");
// #"R9" @SET-SYMBOL %symbol_0;
// #"R9" @PLACE(0, -216) => @ORIENT("R0");
// #"R4" @SET-SYMBOL %symbol_0;
// #"R4" @PLACE(0, -96) => @ORIENT("R0");
// #"R11" @SET-SYMBOL %symbol_0;
// #"R11" @PLACE(0, -264) => @ORIENT("R0");
// #"R14" @SET-SYMBOL %symbol_0;
// #"R14" @PLACE(0, -336) => @ORIENT("R0");
// #"R2" @SET-SYMBOL %symbol_0;
// #"R2" @PLACE(0, -48) => @ORIENT("R0");
// #"R7" @SET-SYMBOL %symbol_0;
// #"R7" @PLACE(0, -168) => @ORIENT("R0");
// {#"R0" #"R0_2__dmy0" #"R0_3__dmy0" #"R0_4__dmy0" #"R0_5__dmy0" #"R0_6__dmy0" #"R0_7__dmy0" #"R0_8__dmy0" #"R0_9__dmy0"} @SET-SYMBOL %expanded_members_symbol;
// {#"R0" #"R0_2__dmy0" #"R0_3__dmy0" #"R0_4__dmy0" #"R0_5__dmy0" #"R0_6__dmy0" #"R0_7__dmy0" #"R0_8__dmy0" #"R0_9__dmy0"} @PLACE(0, 0);
// %expanded_1 = {#"R0" #"R0_2__dmy0" #"R0_3__dmy0" #"R0_4__dmy0" #"R0_5__dmy0" #"R0_6__dmy0" #"R0_7__dmy0" #"R0_8__dmy0" #"R0_9__dmy0"}(parts) #"R0":1(p1) #"R0_9__dmy0":2(p2) @AS %expanded_type_2;
// %expanded_1 @SET-SYMBOL %symbol_1;
// %expanded_1 @PLACE(0, 0) => @ORIENT("R90");
// %expanded_1 @TEXT("R0", key="name");
// %expanded_1 @TEXT("rnods", key="model");
// #"R5" @SET-SYMBOL %symbol_0;
// #"R5" @PLACE(0, -120) => @ORIENT("R0");
// #"R1" @SET-SYMBOL %symbol_0;
// #"R1" @PLACE(0, -24) => @ORIENT("R0");
// #"R3" @SET-SYMBOL %symbol_0;
// #"R3" @PLACE(0, -72) => @ORIENT("R0");
// #"R12" @SET-SYMBOL %symbol_0;
// #"R12" @PLACE(0, -288) => @ORIENT("R0");
// %port_0 = $IO_PORT @ATTACH &"VREFP" => @PLACE(-64, 0) => @ORIENT("R0");
// %port_1 = $IO_PORT @ATTACH &"VREFN" => @PLACE(-64, -8) => @ORIENT("R0");
// %output_port_symbol = @DEFINE-SYMBOL(box=[0, -1, 2, 1]) {
// @LINE(fill="linecolor", linestyle="none") {(0, -0.9) (0, 0.9) (1.1, 0.9) (2, 0) (1.1, -0.9) (0, -0.9)};
// (0, 0) @PIN(terminal=1, direction="left");
// ? @TEXT("${name}", key="name", halign="middle") => @PLACE(1, 1.6)
// };
// %bus_port_type_2 = @DEFINE(roles=[["p", "net"], ["p1", "net"], ["p2", "net"], ["p3", "net"], ["p4", "net"], ["p5", "net"], ["p6", "net"], ["p7", "net"], ["p8", "net"], ["p9", "net"], ["p10", "net"], ["p11", "net"], ["p12", "net"], ["p13", "net"], ["p14", "net"]]) {};
// %bus_port_type_2_symbol = @DEFINE-SYMBOL {(0, 0) @PIN(terminal=[1, 2, 3, 4, 5, 6, 7, 8, 9, 10, 11, 12, 13, 14, 15])};
// {&"VREF_14" &"VREF_13" &"VREF_12" &"VREF_11" &"VREF_10" &"VREF_9" &"VREF_8" &"VREF_7" &"VREF_6" &"VREF_5" &"VREF_4" &"VREF_3" &"VREF_2" &"VREF_1" &"VREF_0"} @REMOVE-FROM $PORT_FILL_SET;
// %port_2 = %bus_port_type_2 @ATTACH &"VREF_14" &"VREF_13" &"VREF_12" &"VREF_11" &"VREF_10" &"VREF_9" &"VREF_8" &"VREF_7" &"VREF_6" &"VREF_5" &"VREF_4" &"VREF_3" &"VREF_2" &"VREF_1" &"VREF_0" => @PLACE(-64, -16) => @ORIENT("R0");
// %port_2 @SET-SYMBOL %bus_port_type_2_symbol;
// %port_2_marker = $IO_PORT @ATTACH &"VREF_14" => @PLACE(-64, -16) => @ORIENT("R0");
// %port_2_marker @SET-SYMBOL %output_port_symbol;
// %port_2_marker @TEXT("VREF<14:0>", key="name");
// %p0 = (0, -16);
// %wire_0 = &"VREF_0" @WIRE(mode="straight") {#"R1":1 %p0};
// %p1 = (14, 0);
// %wire_1 = &"VREF_0" @WIRE(mode="straight") {%expanded_1:p2 %p1};
// %wire_1 @TEXT("VREF\_0", size=1, halign="middle", valign="baseline") => @PLACE(10, 0);
// %wire_0 @TEXT("VREF\_0", size=1, halign="middle", valign="baseline") => @PLACE(0, -20);
// %p2 = (0, -40);
// %wire_2 = &"VREF_1" @WIRE(mode="straight") {#"R2":1 %p2};
// %p3 = (0, -38);
// %wire_3 = &"VREF_1" @WIRE(mode="straight") {%p3 #"R1":2};
// %wire_3 @TEXT("VREF\_1", size=1, halign="middle", valign="baseline") => @PLACE(0, -34);
// %wire_2 @TEXT("VREF\_1", size=1, halign="middle", valign="baseline") => @PLACE(0, -44);
// %p4 = (0, -64);
// %wire_4 = &"VREF_2" @WIRE(mode="straight") {#"R3":1 %p4};
// %p5 = (0, -62);
// %wire_5 = &"VREF_2" @WIRE(mode="straight") {%p5 #"R2":2};
// %wire_5 @TEXT("VREF\_2", size=1, halign="middle", valign="baseline") => @PLACE(0, -58);
// %wire_4 @TEXT("VREF\_2", size=1, halign="middle", valign="baseline") => @PLACE(0, -68);
// %p6 = (0, -88);
// %wire_6 = &"VREF_3" @WIRE(mode="straight") {#"R4":1 %p6};
// %p7 = (0, -86);
// %wire_7 = &"VREF_3" @WIRE(mode="straight") {%p7 #"R3":2};
// %wire_7 @TEXT("VREF\_3", size=1, halign="middle", valign="baseline") => @PLACE(0, -82);
// %wire_6 @TEXT("VREF\_3", size=1, halign="middle", valign="baseline") => @PLACE(0, -92);
// %p8 = (0, -112);
// %wire_8 = &"VREF_4" @WIRE(mode="straight") {#"R5":1 %p8};
// %p9 = (0, -110);
// %wire_9 = &"VREF_4" @WIRE(mode="straight") {%p9 #"R4":2};
// %wire_9 @TEXT("VREF\_4", size=1, halign="middle", valign="baseline") => @PLACE(0, -106);
// %wire_8 @TEXT("VREF\_4", size=1, halign="middle", valign="baseline") => @PLACE(0, -116);
// %p10 = (0, -136);
// %wire_10 = &"VREF_5" @WIRE(mode="straight") {#"R6":1 %p10};
// %p11 = (0, -134);
// %wire_11 = &"VREF_5" @WIRE(mode="straight") {%p11 #"R5":2};
// %wire_11 @TEXT("VREF\_5", size=1, halign="middle", valign="baseline") => @PLACE(0, -130);
// %wire_10 @TEXT("VREF\_5", size=1, halign="middle", valign="baseline") => @PLACE(0, -140);
// %p12 = (0, -160);
// %wire_12 = &"VREF_6" @WIRE(mode="straight") {#"R7":1 %p12};
// %p13 = (0, -158);
// %wire_13 = &"VREF_6" @WIRE(mode="straight") {%p13 #"R6":2};
// %wire_13 @TEXT("VREF\_6", size=1, halign="middle", valign="baseline") => @PLACE(0, -154);
// %wire_12 @TEXT("VREF\_6", size=1, halign="middle", valign="baseline") => @PLACE(0, -164);
// %p14 = (0, -184);
// %wire_14 = &"VREF_7" @WIRE(mode="straight") {#"R8":1 %p14};
// %p15 = (0, -182);
// %wire_15 = &"VREF_7" @WIRE(mode="straight") {%p15 #"R7":2};
// %wire_15 @TEXT("VREF\_7", size=1, halign="middle", valign="baseline") => @PLACE(0, -178);
// %wire_14 @TEXT("VREF\_7", size=1, halign="middle", valign="baseline") => @PLACE(0, -188);
// %p16 = (0, -208);
// %wire_16 = &"VREF_8" @WIRE(mode="straight") {#"R9":1 %p16};
// %p17 = (0, -206);
// %wire_17 = &"VREF_8" @WIRE(mode="straight") {%p17 #"R8":2};
// %wire_17 @TEXT("VREF\_8", size=1, halign="middle", valign="baseline") => @PLACE(0, -202);
// %wire_16 @TEXT("VREF\_8", size=1, halign="middle", valign="baseline") => @PLACE(0, -212);
// %p18 = (0, -232);
// %wire_18 = &"VREF_9" @WIRE(mode="straight") {#"R10":1 %p18};
// %p19 = (0, -230);
// %wire_19 = &"VREF_9" @WIRE(mode="straight") {%p19 #"R9":2};
// %wire_19 @TEXT("VREF\_9", size=1, halign="middle", valign="baseline") => @PLACE(0, -226);
// %wire_18 @TEXT("VREF\_9", size=1, halign="middle", valign="baseline") => @PLACE(0, -236);
// %p20 = (0, -256);
// %wire_20 = &"VREF_10" @WIRE(mode="straight") {#"R11":1 %p20};
// %p21 = (0, -254);
// %wire_21 = &"VREF_10" @WIRE(mode="straight") {%p21 #"R10":2};
// %wire_21 @TEXT("VREF\_10", size=1, halign="middle", valign="baseline") => @PLACE(0, -250);
// %wire_20 @TEXT("VREF\_10", size=1, halign="middle", valign="baseline") => @PLACE(0, -260);
// %p22 = (0, -280);
// %wire_22 = &"VREF_11" @WIRE(mode="straight") {#"R12":1 %p22};
// %p23 = (0, -278);
// %wire_23 = &"VREF_11" @WIRE(mode="straight") {%p23 #"R11":2};
// %wire_23 @TEXT("VREF\_11", size=1, halign="middle", valign="baseline") => @PLACE(0, -274);
// %wire_22 @TEXT("VREF\_11", size=1, halign="middle", valign="baseline") => @PLACE(0, -284);
// %p24 = (0, -304);
// %wire_24 = &"VREF_12" @WIRE(mode="straight") {#"R13":1 %p24};
// %p25 = (0, -302);
// %wire_25 = &"VREF_12" @WIRE(mode="straight") {%p25 #"R12":2};
// %wire_25 @TEXT("VREF\_12", size=1, halign="middle", valign="baseline") => @PLACE(0, -298);
// %wire_24 @TEXT("VREF\_12", size=1, halign="middle", valign="baseline") => @PLACE(0, -308);
// %p26 = (0, -328);
// %wire_26 = &"VREF_13" @WIRE(mode="straight") {#"R14":1 %p26};
// %p27 = (0, -326);
// %wire_27 = &"VREF_13" @WIRE(mode="straight") {%p27 #"R13":2};
// %wire_27 @TEXT("VREF\_13", size=1, halign="middle", valign="baseline") => @PLACE(0, -322);
// %wire_26 @TEXT("VREF\_13", size=1, halign="middle", valign="baseline") => @PLACE(0, -332);
// %p28 = (-8, -360);
// %wire_28 = &"VREF_14" @WIRE(mode="straight") {%p28 %expanded_0:p1};
// %p29 = (0, -350);
// %wire_29 = &"VREF_14" @WIRE(mode="straight") {%p29 #"R14":2};
// %wire_29 @TEXT("VREF\_14", size=1, halign="middle", valign="baseline") => @PLACE(0, -346);
// %wire_28 @TEXT("VREF\_14", size=1, halign="middle", valign="baseline") => @PLACE(-4, -360);
// %p30 = (-57.6, -16);
// %wire_30 = {&"VREF_0" &"VREF_1" &"VREF_2" &"VREF_3" &"VREF_4" &"VREF_5" &"VREF_6" &"VREF_7" &"VREF_8" &"VREF_9" &"VREF_10" &"VREF_11" &"VREF_12" &"VREF_13" &"VREF_14"} @WIRE(mode="straight") {%port_2:1 %p30};
// %wire_30 @TEXT("VREF<14:0>", size=1, halign="middle", valign="middle") => @PLACE(-60.8, -16);
// %p31 = (-57.6, -8);
// %wire_31 = &"VREFN" @WIRE(mode="straight") {%port_1:p %p31};
// %p32 = (-8, 0);
// %wire_32 = &"VREFN" @WIRE(mode="straight") {%p32 %expanded_1:p1};
// %wire_32 @TEXT("VREFN", size=1, halign="middle", valign="baseline") => @PLACE(-4, 0);
// %wire_31 @TEXT("VREFN", size=1, halign="middle", valign="middle") => @PLACE(-60.8, -8);
// %p33 = (-57.6, 0);
// %wire_33 = &"VREFP" @WIRE(mode="straight") {%port_0:p %p33};
// %p34 = (14, -360);
// %wire_34 = &"VREFP" @WIRE(mode="straight") {%expanded_0:p2 %p34};
// %wire_34 @TEXT("VREFP", size=1, halign="middle", valign="baseline") => @PLACE(10, -360);
// %wire_33 @TEXT("VREFP", size=1, halign="middle", valign="middle") => @PLACE(-60.8, 0)
// }
ends L4_stage1_flash4_rdac
//End of R0
