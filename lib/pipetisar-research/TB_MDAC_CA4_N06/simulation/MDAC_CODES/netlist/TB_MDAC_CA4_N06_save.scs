simulator lang=spectre
// Explicit waveform dependencies; keep raw bits out of Maestro Outputs.
save VINP
save VINN
save ROP
save RON
save TRACK
save AMP
save RESET
save K\<0\>
save K\<1\>
save K\<2\>
save K\<3\>
save XDUT.BDP
save XDUT.BDN
save XDUT.XN
save XDUT.XP
save XDUT.BP\<0\>
save XDUT.BP\<1\>
save XDUT.BP\<2\>
save XDUT.BP\<3\>
save XDUT.BN\<0\>
save XDUT.BN\<1\>
save XDUT.BN\<2\>
save XDUT.BN\<3\>
save XDUT.H\<0\>
save XDUT.H\<1\>
save XDUT.H\<2\>
save XDUT.H\<3\>
save XDUT.HB\<0\>
save XDUT.HB\<1\>
save XDUT.HB\<2\>
save XDUT.HB\<3\>
save XDUT.L\<0\>
save XDUT.L\<1\>
save XDUT.L\<2\>
save XDUT.L\<3\>
save XDUT.LB\<0\>
save XDUT.LB\<1\>
save XDUT.LB\<2\>
save XDUT.LB\<3\>
