// Explicit saved-library assembly.
simulator lang=spectre
include "RS9_L5_9bit_Comparator_LN.scs"
