// @RNL(type="header") {
// @VERSION("0.3");
// @USE-PACKAGE(name="rnl-std-spectre", version="0.3", path="rnl-std-spectre.rnl");
// @USE-PACKAGE(name="eda-symbol", version="0.1", path="eda-symbol.rnl");
// @USE-PACKAGE(name="eda-style", version="0.1", path="eda-style.rnl")
// }
// Design: 2026_PIPETISAR_RESEARCH/tb_Buffer_Main
simulator lang=spectre
global 0

// 2026_PIPETISAR_RESEARCH/Buffer_Main/schematic

// 2026_PIPETISAR_RESEARCH/tb_Buffer_Main/schematic
subckt tb_Buffer_Main VOUTN VOUTP
V0 (VCM VSS) vsource dc=500.0m type=dc
V3 (VSS 0) vsource dc=0 type=dc
V1 (VDD VSS) vsource dc=1 type=dc
V10 (VINN VSS) vsource type=sine sinedc=500.0m ampl=-VIN/2 freq=fs*cycle/N
V8 (VINP VSS) vsource type=sine sinedc=500.0m ampl=VIN/2 freq=fs*cycle/N
I0 (VDD VINP VINN VOUTN VOUTP VSS VCM) Buffer_Main
// @RNL(author="rnl-virtuoso") {
// #"V8" @SET-SYMBOL $VSIN;
// #"V8" @PLACE(52, -39) => @ORIENT("R0");
// #"V10" @SET-SYMBOL $VSIN;
// #"V10" @PLACE(60, -39) => @ORIENT("R0");
// #"I0" @PLACE(53, -16) => @ORIENT("R0");
// #"V3" @SET-SYMBOL $VOLTAGE_SOURCE;
// #"V3" @PLACE(76, -39) => @ORIENT("R0");
// #"V1" @SET-SYMBOL $VOLTAGE_SOURCE;
// #"V1" @PLACE(68, -39) => @ORIENT("R0");
// #"V0" @SET-SYMBOL $VOLTAGE_SOURCE;
// #"V0" @PLACE(85, -39) => @ORIENT("R0");
// %marker_0 = $GROUND @ATTACH &"0" => @PLACE(76, -42) => @ORIENT("R0");
// %output_port_symbol = @DEFINE-SYMBOL(box=[0, -1, 2, 1]) {
// @LINE(fill="linecolor", linestyle="none") {(0, -0.9) (0, 0.9) (1.1, 0.9) (2, 0) (1.1, -0.9) (0, -0.9)};
// (0, 0) @PIN(terminal=1, direction="left");
// ? @TEXT("${name}", key="name", halign="middle") => @PLACE(1, 1.6)
// };
// %port_0 = $IO_PORT @ATTACH &"VOUTP" => @PLACE(76, -19) => @ORIENT("R0");
// %port_0 @SET-SYMBOL %output_port_symbol;
// %port_0 @TEXT("VOUTP", key="name");
// %port_1 = $IO_PORT @ATTACH &"VOUTN" => @PLACE(76, -15) => @ORIENT("R0");
// %port_1 @SET-SYMBOL %output_port_symbol;
// %port_1 @TEXT("VOUTN", key="name");
// %wire_0 = &"0" @WIRE(mode="straight") {%marker_0:p #"V3":2};
// %p0 = (85, -32);
// %wire_1 = &"VCM" @WIRE(mode="straight") {#"V0":1 %p0};
// %p1 = (61, -5);
// %wire_2 = &"VCM" @WIRE(mode="straight") {#"I0":7 %p1};
// %wire_2 @TEXT("VCM", size=1, halign="start", valign="baseline", rotate=90) => @PLACE(60.3, -8.6);
// %wire_1 @TEXT("VCM", size=1, halign="start", valign="baseline", rotate=90) => @PLACE(84.3, -35.6);
// %p2 = (85, -46);
// %wire_3 = &"VSS" @WIRE(mode="straight") {%p2 #"V0":2};
// %p3 = (60, -46);
// %wire_4 = &"VSS" @WIRE(mode="straight") {%p3 #"V10":2};
// %p4 = (52, -46);
// %wire_5 = &"VSS" @WIRE(mode="straight") {%p4 #"V8":2};
// %p5 = (76, -32);
// %wire_6 = &"VSS" @WIRE(mode="straight") {#"V3":1 %p5};
// %p6 = (68, -46);
// %wire_7 = &"VSS" @WIRE(mode="straight") {%p6 #"V1":2};
// %p7 = (63, -29);
// %wire_8 = &"VSS" @WIRE(mode="straight") {%p7 #"I0":6};
// %wire_8 @TEXT("VSS", size=1, halign="end", valign="baseline", rotate=90) => @PLACE(62.3, -25.4);
// %wire_7 @TEXT("VSS", size=1, halign="end", valign="baseline", rotate=90) => @PLACE(67.3, -42.4);
// %wire_6 @TEXT("VSS", size=1, halign="start", valign="baseline", rotate=90) => @PLACE(75.3, -35.6);
// %wire_5 @TEXT("VSS", size=1, halign="end", valign="baseline", rotate=90) => @PLACE(51.3, -42.4);
// %wire_4 @TEXT("VSS", size=1, halign="end", valign="baseline", rotate=90) => @PLACE(59.3, -42.4);
// %wire_3 @TEXT("VSS", size=1, halign="end", valign="baseline", rotate=90) => @PLACE(84.3, -42.4);
// %p8 = (52, -32);
// %wire_9 = &"VINP" @WIRE(mode="straight") {#"V8":1 %p8};
// %p9 = (49, -19);
// %wire_10 = &"VINP" @WIRE(mode="straight") {%p9 #"I0":2};
// %wire_10 @TEXT("VINP", size=1, halign="end", valign="baseline") => @PLACE(52.6, -18.3);
// %wire_9 @TEXT("VINP", size=1, halign="start", valign="baseline", rotate=90) => @PLACE(51.3, -35.6);
// %p10 = (60, -32);
// %wire_11 = &"VINN" @WIRE(mode="straight") {#"V10":1 %p10};
// %p11 = (49, -15);
// %wire_12 = &"VINN" @WIRE(mode="straight") {%p11 #"I0":3};
// %wire_12 @TEXT("VINN", size=1, halign="end", valign="baseline") => @PLACE(52.6, -14.3);
// %wire_11 @TEXT("VINN", size=1, halign="start", valign="baseline", rotate=90) => @PLACE(59.3, -35.6);
// %p12 = (68, -32);
// %wire_13 = &"VDD" @WIRE(mode="straight") {#"V1":1 %p12};
// %p13 = (63, -6);
// %wire_14 = &"VDD" @WIRE(mode="straight") {#"I0":1 %p13};
// %wire_14 @TEXT("VDD", size=1, halign="start", valign="baseline", rotate=90) => @PLACE(62.3, -9.6);
// %wire_13 @TEXT("VDD", size=1, halign="start", valign="baseline", rotate=90) => @PLACE(67.3, -35.6);
// %wire_15 = &"VOUTN" @WIRE(mode="straight") {#"I0":4 %port_1:p};
// %wire_15 @TEXT("VOUTN", size=1, halign="start", valign="baseline") => @PLACE(70.4, -14.3);
// %wire_16 = &"VOUTP" @WIRE(mode="straight") {#"I0":5 %port_0:p};
// %wire_16 @TEXT("VOUTP", size=1, halign="start", valign="baseline") => @PLACE(70.4, -18.3)
// }
ends tb_Buffer_Main
