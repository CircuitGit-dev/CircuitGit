// Explicit saved-library assembly.
simulator lang=spectre
include "L4_stage1_flash4_rdac_FS2.scs"
