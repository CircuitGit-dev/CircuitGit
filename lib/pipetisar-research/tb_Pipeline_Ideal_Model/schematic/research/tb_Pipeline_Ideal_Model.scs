// @RNL(type="header") {
// @VERSION("0.3");
// @USE-PACKAGE(name="rnl-std-spectre", version="0.3", path="rnl-std-spectre.rnl");
// @USE-PACKAGE(name="eda-symbol", version="0.1", path="eda-symbol.rnl");
// @USE-PACKAGE(name="eda-style", version="0.1", path="eda-style.rnl")
// }
// Design: 2026_PIPETISAR_RESEARCH/tb_Pipeline_Ideal_Model
simulator lang=spectre
global 0

// dataconverter_lib/OTA_Diff/schematic

// 2026_PIPETISAR_RESEARCH/Amplifier_Main/schematic

// 2026_PIPETISAR_RESEARCH/tb_Pipeline_Ideal_Model/schematic
subckt tb_Pipeline_Ideal_Model VOUTP VOUTN
C7 (net6 net5) capacitor c=100f
C6 (net7 net4) capacitor c=100f
C5 (net2 net12) capacitor c=200f
C4 (VOP net2) capacitor c=100f
C3 (net1 net11) capacitor c=200f
C2 (VON net1) capacitor c=100f
C1 (net10 net8) capacitor c=100f
C0 (net3 net9) capacitor c=100f
V10 (VINN VSS) vsource type=sine sinedc=500.0m ampl=-VIN/2 freq=fs*cycle/N
V8 (VINP VSS) vsource type=sine sinedc=500.0m ampl=VIN/2 freq=fs*cycle/N
W19 (VCM net12 PHI2 VSS) relay ropen=1T rclosed=1.0
W18 (VINN net12 PHI1 VSS) relay ropen=1T rclosed=1.0
W15 (VCP net6 PHI2 VSS) relay ropen=1T rclosed=1.0
W14 (VCN net7 PHI2 VSS) relay ropen=1T rclosed=1.0
W13 (VCM net5 PHI1 VSS) relay ropen=1T rclosed=1.0
W12 (VON net5 PHI2 VSS) relay ropen=1T rclosed=1.0
W11 (VCM net4 PHI1 VSS) relay ropen=1T rclosed=1.0
W10 (VCM VOP PHI1 VSS) relay ropen=1T rclosed=1.0
W9 (VCM VON PHI1 VSS) relay ropen=1T rclosed=1.0
W8 (VCM net2 PHI1E VSS) relay ropen=1T rclosed=1.0
W7 (VCM net1 PHI1E VSS) relay ropen=1T rclosed=1.0
W6 (VCM net10 PHI1E VSS) relay ropen=1T rclosed=1.0
W5 (VINN net3 PHI1E VSS) relay ropen=1T rclosed=1.0
W4 (VOP net4 PHI2 VSS) relay ropen=1T rclosed=1.0
W3 (VCM net8 PHI2 VSS) relay ropen=1T rclosed=1.0
W2 (VCM net9 PHI2 VSS) relay ropen=1T rclosed=1.0
W1 (VINN net8 PHI1 VSS) relay ropen=1T rclosed=1.0
W0 (VINP net9 PHI1 VSS) relay ropen=1T rclosed=1.0
W17 (VCM net11 PHI2 VSS) relay ropen=1T rclosed=1.0
W16 (VINP net11 PHI1 VSS) relay ropen=1T rclosed=1.0
I2 (VCM VDD net7 net6 VOUTP VOUTN) OTA_Diff gm=10m gm_id=10 Gain=1
I1 (VCM VDD net1 net2 VCP VCN) OTA_Diff gm=10m gm_id=10 Gain=3
V4 (VCM VSS) vsource dc=500.0m type=dc
V3 (VSS 0) vsource dc=0 type=dc
V1 (VDD VSS) vsource dc=1 type=dc
V7 (PHI2 VSS) vsource type=pulse val0=0 val1=1 period=1n delay=500p rise=10p fall=10p width=480p
V6 (PHI1E VSS) vsource type=pulse val0=0 val1=1 period=1n rise=10p fall=10p width=460p
V5 (PHI1 VSS) vsource type=pulse val0=0 val1=1 period=1n rise=10p fall=10p width=480p
I5 (VDD net10 net3 VON VOP VSS) Amplifier_Main
// @RNL(author="rnl-virtuoso") {
// #"W19" @SET-SYMBOL $VOLTAGE_CONTROLLED_SWITCH;
// #"W19" @PLACE(46, -41) => @ORIENT("MY");
// #"C5" @SET-SYMBOL $CAPACITOR;
// #"C5" @PLACE(36, -33) => @ORIENT("MY");
// #"W17" @SET-SYMBOL $VOLTAGE_CONTROLLED_SWITCH;
// #"W17" @PLACE(46, 25) => @ORIENT("R180");
// #"W1" @SET-SYMBOL $VOLTAGE_CONTROLLED_SWITCH;
// #"W1" @PLACE(-26, -17) => @ORIENT("R0");
// #"C1" @SET-SYMBOL $CAPACITOR;
// #"C1" @PLACE(-9, -15) => @ORIENT("MXR90");
// #"V6" @SET-SYMBOL $VPULSE;
// #"V6" @PLACE(115, -47) => @ORIENT("R0");
// #"W13" @SET-SYMBOL $VOLTAGE_CONTROLLED_SWITCH;
// #"W13" @PLACE(99, -29) => @ORIENT("R90");
// #"C0" @SET-SYMBOL $CAPACITOR;
// #"C0" @PLACE(-9, -2) => @ORIENT("R270");
// #"C6" @SET-SYMBOL $CAPACITOR;
// #"C6" @PLACE(104, 2) => @ORIENT("R270");
// #"W5" @SET-SYMBOL $VOLTAGE_CONTROLLED_SWITCH;
// #"W5" @PLACE(-4, 12) => @ORIENT("R270");
// #"V8" @SET-SYMBOL $VSIN;
// #"V8" @PLACE(64, -47) => @ORIENT("R0");
// #"C3" @SET-SYMBOL $CAPACITOR;
// #"C3" @PLACE(36, 17) => @ORIENT("R180");
// #"W15" @SET-SYMBOL $VOLTAGE_CONTROLLED_SWITCH;
// #"W15" @PLACE(117, -29) => @ORIENT("R90");
// #"W12" @SET-SYMBOL $VOLTAGE_CONTROLLED_SWITCH;
// #"W12" @PLACE(87, -20) => @ORIENT("R0");
// #"W8" @SET-SYMBOL $VOLTAGE_CONTROLLED_SWITCH;
// #"W8" @PLACE(58, -29) => @ORIENT("MY");
// #"W7" @SET-SYMBOL $VOLTAGE_CONTROLLED_SWITCH;
// #"W7" @PLACE(58, 13) => @ORIENT("R180");
// #"W16" @SET-SYMBOL $VOLTAGE_CONTROLLED_SWITCH;
// #"W16" @PLACE(34, 29) => @ORIENT("R270");
// #"W2" @SET-SYMBOL $VOLTAGE_CONTROLLED_SWITCH;
// #"W2" @PLACE(-17, 12) => @ORIENT("R270");
// #"I5" @PLACE(3, -7) => @ORIENT("R0");
// #"W18" @SET-SYMBOL $VOLTAGE_CONTROLLED_SWITCH;
// #"W18" @PLACE(34, -45) => @ORIENT("MXR90");
// #"V10" @SET-SYMBOL $VSIN;
// #"V10" @PLACE(72, -47) => @ORIENT("R0");
// #"W14" @SET-SYMBOL $VOLTAGE_CONTROLLED_SWITCH;
// #"W14" @PLACE(117, 13) => @ORIENT("MYR90");
// #"V4" @SET-SYMBOL $VOLTAGE_SOURCE;
// #"V4" @PLACE(97, -47) => @ORIENT("R0");
// #"W11" @SET-SYMBOL $VOLTAGE_CONTROLLED_SWITCH;
// #"W11" @PLACE(99, 13) => @ORIENT("MYR90");
// #"V5" @SET-SYMBOL $VPULSE;
// #"V5" @PLACE(106, -47) => @ORIENT("R0");
// #"V3" @SET-SYMBOL $VOLTAGE_SOURCE;
// #"V3" @PLACE(88, -47) => @ORIENT("R0");
// #"V7" @SET-SYMBOL $VPULSE;
// #"V7" @PLACE(124, -47) => @ORIENT("R0");
// #"W0" @SET-SYMBOL $VOLTAGE_CONTROLLED_SWITCH;
// #"W0" @PLACE(-26, 0) => @ORIENT("MX");
// %symbol_0 = @DEFINE-SYMBOL(box=[10, -5, 30, 7]) {
// @LINE {(20, 7) (20, 5)};
// (13, -1) @CIRCLE(radius=1);
// @LINE {(30, -1) (26, -1)};
// (27, 3) @CIRCLE(radius=1);
// @LINE {(10, 3) (14, 3)};
// @LINE {(30, 1) (26, 1)};
// @LINE {(28, 3) (30, 3)};
// @LINE {(10, -1) (12, -1)};
// @LINE {(14, 7) (14, -5) (26, 1) (14, 7)};
// ? @TEXT("${model}", size=1, halign="middle", valign="middle", key="model") => @PLACE(18, 1);
// ? @TEXT("${name}", size=1, halign="start", valign="middle", key="name") => @PLACE(14, 8);
// (10, 3) @PIN(terminal=3);
// (14.6, 3) @TEXT("Vin", size=1, halign="start", valign="middle");
// (20, 7) @PIN(terminal=2);
// (19, 6.4) @TEXT("Vdd", size=1, halign="end", valign="middle", rotate=90);
// (30, 3) @PIN(terminal=6);
// (25.4, 3) @TEXT("Voutb", size=1, halign="end", valign="middle");
// (30, 1) @PIN(terminal=1);
// (25.4, 1) @TEXT("Vcmo", size=1, halign="end", valign="middle");
// (10, -1) @PIN(terminal=4);
// (14.6, -1) @TEXT("Vinb", size=1, halign="start", valign="middle");
// (30, -1) @PIN(terminal=5);
// (25.4, -1) @TEXT("Vout", size=1, halign="end", valign="middle")
// };
// #"I1" @SET-SYMBOL %symbol_0;
// #"I1" @PLACE(38, -9) => @ORIENT("R0");
// #"W4" @SET-SYMBOL $VOLTAGE_CONTROLLED_SWITCH;
// #"W4" @PLACE(87, 4) => @ORIENT("MX");
// #"C4" @SET-SYMBOL $CAPACITOR;
// #"C4" @PLACE(36, -20) => @ORIENT("MY");
// #"V1" @SET-SYMBOL $VOLTAGE_SOURCE;
// #"V1" @PLACE(80, -47) => @ORIENT("R0");
// #"W3" @SET-SYMBOL $VOLTAGE_CONTROLLED_SWITCH;
// #"W3" @PLACE(-17, -29) => @ORIENT("MXR90");
// #"W6" @SET-SYMBOL $VOLTAGE_CONTROLLED_SWITCH;
// #"W6" @PLACE(-4, -29) => @ORIENT("MXR90");
// #"I2" @SET-SYMBOL %symbol_0;
// #"I2" @PLACE(110, -8) => @ORIENT("R0");
// #"W9" @SET-SYMBOL $VOLTAGE_CONTROLLED_SWITCH;
// #"W9" @PLACE(24, 8) => @ORIENT("R270");
// #"W10" @SET-SYMBOL $VOLTAGE_CONTROLLED_SWITCH;
// #"W10" @PLACE(24, -24) => @ORIENT("MXR90");
// #"C2" @SET-SYMBOL $CAPACITOR;
// #"C2" @PLACE(36, 4) => @ORIENT("R180");
// #"C7" @SET-SYMBOL $CAPACITOR;
// #"C7" @PLACE(104, -18) => @ORIENT("MXR90");
// %marker_6 = $GROUND @ATTACH &"0" => @PLACE(88, -50) => @ORIENT("R0");
// %output_port_symbol = @DEFINE-SYMBOL(box=[0, -1, 2, 1]) {
// @LINE(fill="linecolor", linestyle="none") {(0, -0.9) (0, 0.9) (1.1, 0.9) (2, 0) (1.1, -0.9) (0, -0.9)};
// (0, 0) @PIN(terminal=1, direction="left");
// ? @TEXT("${name}", key="name", halign="middle") => @PLACE(1, 1.6)
// };
// %port_0 = $IO_PORT @ATTACH &"VOUTN" => @PLACE(145, -5) => @ORIENT("R0");
// %port_0 @SET-SYMBOL %output_port_symbol;
// %port_0 @TEXT("VOUTN", key="name");
// %port_1 = $IO_PORT @ATTACH &"VOUTP" => @PLACE(145, -9) => @ORIENT("R0");
// %port_1 @SET-SYMBOL %output_port_symbol;
// %port_1 @TEXT("VOUTP", key="name");
// %wire_0 = &"0" @WIRE(mode="straight") {%marker_6:p #"V3":2};
// %p0 = (36, -39);
// %wire_1 = &"net12" @WIRE(mode="straight") {%p0 #"W19":2};
// %wire_2 = &"net12" @WIRE(mode="straight") {%p0 #"C5":2};
// %wire_3 = &"net12" @WIRE(mode="straight") {#"W18":2 %p0};
// %p1 = (36, 23);
// %wire_4 = &"net11" @WIRE(mode="straight") {%p1 #"W17":2};
// %wire_5 = &"net11" @WIRE(mode="straight") {%p1 #"W16":2};
// %wire_6 = &"net11" @WIRE(mode="straight") {#"C3":2 %p1};
// %p2 = (-2, -10);
// %wire_7 = &"net10" @WIRE(mode="straight") {%p2 #"I5":2};
// %p3 = (-2, -15);
// %wire_8 = &"net10" @WIRE(mode="straight") {%p3 #"W6":2};
// %wire_9 = &"net10" @WIRE(mode="straight") {#"C1":1 %p3};
// %wire_10 = &"net10" @WIRE(mode="straight") {%p3 %p2};
// %p4 = (-15, -2);
// %wire_11 = &"net9" @WIRE(mode="straight") {%p4 #"W2":2};
// %wire_12 = &"net9" @WIRE(mode="straight") {%p4 #"C0":2};
// %wire_13 = &"net9" @WIRE(mode="straight") {#"W0":2 %p4};
// %p5 = (-15, -15);
// %wire_14 = &"net8" @WIRE(mode="straight") {%p5 #"C1":2};
// %wire_15 = &"net8" @WIRE(mode="straight") {%p5 #"W3":2};
// %wire_16 = &"net8" @WIRE(mode="straight") {#"W1":2 %p5};
// %p6 = (115, -5);
// %p7 = (115, 2);
// %wire_17 = &"net7" @WIRE(mode="straight") {%p6 %p7};
// %wire_18 = &"net7" @WIRE(mode="straight") {%p6 #"I2":3};
// %wire_19 = &"net7" @WIRE(mode="straight") {#"C6":1 %p7};
// %wire_20 = &"net7" @WIRE(mode="straight") {%p7 #"W14":2};
// %p8 = (115, -18);
// %p9 = (115, -9);
// %wire_21 = &"net6" @WIRE(mode="straight") {%p8 %p9};
// %wire_22 = &"net6" @WIRE(mode="straight") {#"C7":1 %p8};
// %wire_23 = &"net6" @WIRE(mode="straight") {%p8 #"W15":2};
// %wire_24 = &"net6" @WIRE(mode="straight") {%p9 #"I2":4};
// %p10 = (97, -18);
// %wire_25 = &"net5" @WIRE(mode="straight") {%p10 #"W13":2};
// %wire_26 = &"net5" @WIRE(mode="straight") {%p10 #"C7":2};
// %wire_27 = &"net5" @WIRE(mode="straight") {#"W12":2 %p10};
// %p11 = (97, 2);
// %wire_28 = &"net4" @WIRE(mode="straight") {%p11 #"W11":2};
// %wire_29 = &"net4" @WIRE(mode="straight") {%p11 #"C6":2};
// %wire_30 = &"net4" @WIRE(mode="straight") {#"W4":2 %p11};
// %p12 = (-2, -2);
// %wire_31 = &"net3" @WIRE(mode="straight") {%p12 #"W5":2};
// %p13 = (-2, -6);
// %wire_32 = &"net3" @WIRE(mode="straight") {%p13 #"I5":3};
// %wire_33 = &"net3" @WIRE(mode="straight") {%p13 %p12};
// %wire_34 = &"net3" @WIRE(mode="straight") {#"C0":1 %p12};
// %p14 = (44, -27);
// %wire_35 = &"net2" @WIRE(mode="straight") {%p14 #"W8":2};
// %p15 = (36, -27);
// %wire_36 = &"net2" @WIRE(mode="straight") {%p15 %p14};
// %wire_37 = &"net2" @WIRE(mode="straight") {%p15 #"C4":2};
// %p16 = (44, -10);
// %wire_38 = &"net2" @WIRE(mode="straight") {%p14 %p16};
// %wire_39 = &"net2" @WIRE(mode="straight") {%p16 #"I1":4};
// %wire_40 = &"net2" @WIRE(mode="straight") {#"C5":1 %p15};
// %p17 = (44, 11);
// %wire_41 = &"net1" @WIRE(mode="straight") {%p17 #"W7":2};
// %p18 = (36, 11);
// %wire_42 = &"net1" @WIRE(mode="straight") {%p18 %p17};
// %wire_43 = &"net1" @WIRE(mode="straight") {%p18 #"C3":1};
// %p19 = (44, -6);
// %wire_44 = &"net1" @WIRE(mode="straight") {%p19 %p17};
// %wire_45 = &"net1" @WIRE(mode="straight") {#"C2":2 %p18};
// %wire_46 = &"net1" @WIRE(mode="straight") {%p19 #"I1":3};
// %p20 = (39, -43);
// %wire_47 = &"VSS" @WIRE(mode="straight") {#"W19":4 %p20};
// %p21 = (32, -38);
// %wire_48 = &"VSS" @WIRE(mode="straight") {#"W18":4 %p21};
// %p22 = (39, 27);
// %wire_49 = &"VSS" @WIRE(mode="straight") {#"W17":4 %p22};
// %p23 = (72, -54);
// %wire_50 = &"VSS" @WIRE(mode="straight") {%p23 #"V10":2};
// %p24 = (64, -54);
// %wire_51 = &"VSS" @WIRE(mode="straight") {%p24 #"V8":2};
// %p25 = (124, -54);
// %wire_52 = &"VSS" @WIRE(mode="straight") {%p25 #"V7":2};
// %p26 = (115, -54);
// %wire_53 = &"VSS" @WIRE(mode="straight") {%p26 #"V6":2};
// %p27 = (106, -54);
// %wire_54 = &"VSS" @WIRE(mode="straight") {%p27 #"V5":2};
// %p28 = (97, -54);
// %wire_55 = &"VSS" @WIRE(mode="straight") {%p28 #"V4":2};
// %p29 = (88, -40);
// %wire_56 = &"VSS" @WIRE(mode="straight") {#"V3":1 %p29};
// %p30 = (80, -54);
// %wire_57 = &"VSS" @WIRE(mode="straight") {%p30 #"V1":2};
// %p31 = (119, -22);
// %wire_58 = &"VSS" @WIRE(mode="straight") {#"W15":4 %p31};
// %p32 = (119, 6);
// %wire_59 = &"VSS" @WIRE(mode="straight") {#"W14":4 %p32};
// %p33 = (94, -22);
// %wire_60 = &"VSS" @WIRE(mode="straight") {#"W12":4 %p33};
// %p34 = (101, -22);
// %wire_61 = &"VSS" @WIRE(mode="straight") {#"W13":4 %p34};
// %p35 = (22, -17);
// %wire_62 = &"VSS" @WIRE(mode="straight") {#"W10":4 %p35};
// %p36 = (22, 1);
// %wire_63 = &"VSS" @WIRE(mode="straight") {#"W9":4 %p36};
// %p37 = (51, -31);
// %wire_64 = &"VSS" @WIRE(mode="straight") {#"W8":4 %p37};
// %p38 = (51, 15);
// %wire_65 = &"VSS" @WIRE(mode="straight") {#"W7":4 %p38};
// %p39 = (-6, -22);
// %wire_66 = &"VSS" @WIRE(mode="straight") {#"W6":4 %p39};
// %p40 = (13, -20);
// %wire_67 = &"VSS" @WIRE(mode="straight") {%p40 #"I5":6};
// %p41 = (-6, 5);
// %wire_68 = &"VSS" @WIRE(mode="straight") {#"W5":4 %p41};
// %p42 = (94, 6);
// %wire_69 = &"VSS" @WIRE(mode="straight") {#"W4":4 %p42};
// %p43 = (101, 6);
// %wire_70 = &"VSS" @WIRE(mode="straight") {#"W11":4 %p43};
// %p44 = (32, 22);
// %wire_71 = &"VSS" @WIRE(mode="straight") {#"W16":4 %p44};
// %p45 = (-19, -22);
// %wire_72 = &"VSS" @WIRE(mode="straight") {#"W3":4 %p45};
// %p46 = (-19, 5);
// %wire_73 = &"VSS" @WIRE(mode="straight") {#"W2":4 %p46};
// %p47 = (-19, -19);
// %wire_74 = &"VSS" @WIRE(mode="straight") {#"W1":4 %p47};
// %p48 = (-19, 2);
// %wire_75 = &"VSS" @WIRE(mode="straight") {#"W0":4 %p48};
// %wire_75 @TEXT("VSS", size=1, halign="start", valign="baseline") => @PLACE(-22.6, 2.7);
// %wire_74 @TEXT("VSS", size=1, halign="start", valign="top") => @PLACE(-22.6, -19.7);
// %wire_73 @TEXT("VSS", size=1, halign="end", valign="baseline", rotate=90) => @PLACE(-19.7, 8.6);
// %wire_72 @TEXT("VSS", size=1, halign="start", valign="baseline", rotate=90) => @PLACE(-19.7, -25.6);
// %wire_67 @TEXT("VSS", size=1, halign="end", valign="baseline", rotate=90) => @PLACE(12.3, -16.4);
// %wire_71 @TEXT("VSS", size=1, halign="end", valign="baseline", rotate=90) => @PLACE(31.3, 25.6);
// %wire_70 @TEXT("VSS", size=1, halign="end", valign="top", rotate=90) => @PLACE(101.7, 9.6);
// %wire_69 @TEXT("VSS", size=1, halign="start", valign="baseline") => @PLACE(90.4, 6.7);
// %wire_68 @TEXT("VSS", size=1, halign="end", valign="baseline", rotate=90) => @PLACE(-6.7, 8.6);
// %wire_66 @TEXT("VSS", size=1, halign="start", valign="baseline", rotate=90) => @PLACE(-6.7, -25.6);
// %wire_65 @TEXT("VSS", size=1, halign="end", valign="baseline") => @PLACE(54.6, 15.7);
// %wire_64 @TEXT("VSS", size=1, halign="end", valign="top") => @PLACE(54.6, -31.7);
// %wire_63 @TEXT("VSS", size=1, halign="end", valign="baseline", rotate=90) => @PLACE(21.3, 4.6);
// %wire_62 @TEXT("VSS", size=1, halign="start", valign="baseline", rotate=90) => @PLACE(21.3, -20.6);
// %wire_61 @TEXT("VSS", size=1, halign="start", valign="top", rotate=90) => @PLACE(101.7, -25.6);
// %wire_60 @TEXT("VSS", size=1, halign="start", valign="top") => @PLACE(90.4, -22.7);
// %wire_59 @TEXT("VSS", size=1, halign="end", valign="top", rotate=90) => @PLACE(119.7, 9.6);
// %wire_58 @TEXT("VSS", size=1, halign="start", valign="top", rotate=90) => @PLACE(119.7, -25.6);
// %wire_57 @TEXT("VSS", size=1, halign="end", valign="baseline", rotate=90) => @PLACE(79.3, -50.4);
// %wire_56 @TEXT("VSS", size=1, halign="start", valign="baseline", rotate=90) => @PLACE(87.3, -43.6);
// %wire_55 @TEXT("VSS", size=1, halign="end", valign="baseline", rotate=90) => @PLACE(96.3, -50.4);
// %wire_54 @TEXT("VSS", size=1, halign="end", valign="baseline", rotate=90) => @PLACE(105.3, -50.4);
// %wire_53 @TEXT("VSS", size=1, halign="end", valign="baseline", rotate=90) => @PLACE(114.3, -50.4);
// %wire_52 @TEXT("VSS", size=1, halign="end", valign="baseline", rotate=90) => @PLACE(123.3, -50.4);
// %wire_51 @TEXT("VSS", size=1, halign="end", valign="baseline", rotate=90) => @PLACE(63.3, -50.4);
// %wire_50 @TEXT("VSS", size=1, halign="end", valign="baseline", rotate=90) => @PLACE(71.3, -50.4);
// %wire_49 @TEXT("VSS", size=1, halign="end", valign="baseline") => @PLACE(42.6, 27.7);
// %wire_48 @TEXT("VSS", size=1, halign="start", valign="baseline", rotate=90) => @PLACE(31.3, -41.6);
// %wire_47 @TEXT("VSS", size=1, halign="end", valign="top") => @PLACE(42.6, -43.7);
// %p49 = (26, -10);
// %p50 = (36, -10);
// %wire_76 = &"VOP" @WIRE(mode="straight") {%p49 %p50};
// %wire_77 = &"VOP" @WIRE(mode="straight") {%p49 #"W10":2};
// %p51 = (80, 2);
// %wire_78 = &"VOP" @WIRE(mode="straight") {%p51 #"W4":1};
// %wire_79 = &"VOP" @WIRE(mode="straight") {#"C4":1 %p50};
// %wire_80 = &"VOP" @WIRE(mode="straight") {#"I5":5 %p49};
// %wire_76 @TEXT("VOP", size=1, halign="start", valign="baseline") => @PLACE(32.4, -9.3);
// %wire_78 @TEXT("VOP", size=1, halign="start", valign="baseline") => @PLACE(80.7, 2.7);
// %p52 = (80, -18);
// %wire_81 = &"VON" @WIRE(mode="straight") {%p52 #"W12":1};
// %p53 = (26, -6);
// %p54 = (36, -6);
// %wire_82 = &"VON" @WIRE(mode="straight") {%p53 %p54};
// %wire_83 = &"VON" @WIRE(mode="straight") {%p53 #"W9":2};
// %wire_84 = &"VON" @WIRE(mode="straight") {#"I5":4 %p53};
// %wire_85 = &"VON" @WIRE(mode="straight") {%p54 #"C2":1};
// %wire_82 @TEXT("VON", size=1, halign="start", valign="baseline") => @PLACE(32.4, -5.3);
// %wire_81 @TEXT("VON", size=1, halign="start", valign="top") => @PLACE(80.7, -18.7);
// %p55 = (64, -40);
// %wire_86 = &"VINP" @WIRE(mode="straight") {#"V8":1 %p55};
// %p56 = (36, 36);
// %wire_87 = &"VINP" @WIRE(mode="straight") {#"W16":1 %p56};
// %p57 = (-38, -2);
// %wire_88 = &"VINP" @WIRE(mode="straight") {%p57 #"W0":1};
// %wire_88 @TEXT("VINP", size=1, halign="start", valign="baseline") => @PLACE(-36.6, -1.3);
// %wire_87 @TEXT("VINP", size=1, halign="start", valign="baseline", rotate=90) => @PLACE(35.3, 32.4);
// %wire_86 @TEXT("VINP", size=1, halign="start", valign="baseline", rotate=90) => @PLACE(63.3, -43.6);
// %p58 = (36, -52);
// %wire_89 = &"VINN" @WIRE(mode="straight") {#"W18":1 %p58};
// %p59 = (72, -40);
// %wire_90 = &"VINN" @WIRE(mode="straight") {#"V10":1 %p59};
// %p60 = (-2, 19);
// %wire_91 = &"VINN" @WIRE(mode="straight") {#"W5":1 %p60};
// %p61 = (-38, -15);
// %wire_92 = &"VINN" @WIRE(mode="straight") {%p61 #"W1":1};
// %wire_92 @TEXT("VINN", size=1, halign="start", valign="baseline") => @PLACE(-36.6, -14.3);
// %wire_91 @TEXT("VINN", size=1, halign="start", valign="baseline", rotate=90) => @PLACE(-2.7, 15.4);
// %wire_90 @TEXT("VINN", size=1, halign="start", valign="baseline", rotate=90) => @PLACE(71.3, -43.6);
// %wire_89 @TEXT("VINN", size=1, halign="end", valign="baseline", rotate=90) => @PLACE(35.3, -48.4);
// %p62 = (13, 3);
// %wire_93 = &"VDD" @WIRE(mode="straight") {#"I5":1 %p62};
// %p63 = (80, -40);
// %wire_94 = &"VDD" @WIRE(mode="straight") {#"V1":1 %p63};
// %p64 = (130, 3);
// %wire_95 = &"VDD" @WIRE(mode="straight") {#"I2":2 %p64};
// %p65 = (58, 2);
// %wire_96 = &"VDD" @WIRE(mode="straight") {#"I1":2 %p65};
// %wire_96 @TEXT("VDD", size=1, halign="start", valign="baseline", rotate=90) => @PLACE(57.3, -1.6);
// %wire_95 @TEXT("VDD", size=1, halign="start", valign="baseline", rotate=90) => @PLACE(129.3, -0.6);
// %wire_94 @TEXT("VDD", size=1, halign="start", valign="baseline", rotate=90) => @PLACE(79.3, -43.6);
// %wire_93 @TEXT("VDD", size=1, halign="start", valign="baseline", rotate=90) => @PLACE(12.3, -0.6);
// %p66 = (115, -36);
// %wire_97 = &"VCP" @WIRE(mode="straight") {%p66 #"W15":1};
// %p67 = (72, -10);
// %wire_98 = &"VCP" @WIRE(mode="straight") {#"I1":5 %p67};
// %wire_98 @TEXT("VCP", size=1, halign="start", valign="baseline") => @PLACE(68.4, -9.3);
// %wire_97 @TEXT("VCP", size=1, halign="start", valign="top", rotate=90) => @PLACE(115.7, -35.3);
// %p68 = (115, 20);
// %wire_99 = &"VCN" @WIRE(mode="straight") {%p68 #"W14":1};
// %p69 = (72, -6);
// %wire_100 = &"VCN" @WIRE(mode="straight") {#"I1":6 %p69};
// %wire_100 @TEXT("VCN", size=1, halign="start", valign="baseline") => @PLACE(68.4, -5.3);
// %wire_99 @TEXT("VCN", size=1, halign="end", valign="top", rotate=90) => @PLACE(115.7, 19.3);
// %p70 = (53, -39);
// %wire_101 = &"VCM" @WIRE(mode="straight") {#"W19":1 %p70};
// %p71 = (53, 23);
// %wire_102 = &"VCM" @WIRE(mode="straight") {#"W17":1 %p71};
// %p72 = (97, -40);
// %wire_103 = &"VCM" @WIRE(mode="straight") {#"V4":1 %p72};
// %p73 = (144, -7);
// %wire_104 = &"VCM" @WIRE(mode="straight") {#"I2":1 %p73};
// %p74 = (97, -36);
// %wire_105 = &"VCM" @WIRE(mode="straight") {%p74 #"W13":1};
// %p75 = (97, 20);
// %wire_106 = &"VCM" @WIRE(mode="straight") {%p75 #"W11":1};
// %p76 = (26, 15);
// %wire_107 = &"VCM" @WIRE(mode="straight") {#"W9":1 %p76};
// %p77 = (65, -27);
// %wire_108 = &"VCM" @WIRE(mode="straight") {#"W8":1 %p77};
// %p78 = (65, 11);
// %wire_109 = &"VCM" @WIRE(mode="straight") {#"W7":1 %p78};
// %p79 = (-2, -36);
// %wire_110 = &"VCM" @WIRE(mode="straight") {#"W6":1 %p79};
// %p80 = (72, -8);
// %wire_111 = &"VCM" @WIRE(mode="straight") {#"I1":1 %p80};
// %p81 = (26, -31);
// %wire_112 = &"VCM" @WIRE(mode="straight") {#"W10":1 %p81};
// %p82 = (-15, -36);
// %wire_113 = &"VCM" @WIRE(mode="straight") {#"W3":1 %p82};
// %p83 = (-15, 19);
// %wire_114 = &"VCM" @WIRE(mode="straight") {#"W2":1 %p83};
// %wire_114 @TEXT("VCM", size=1, halign="start", valign="baseline", rotate=90) => @PLACE(-15.7, 15.4);
// %wire_113 @TEXT("VCM", size=1, halign="end", valign="baseline", rotate=90) => @PLACE(-15.7, -32.4);
// %wire_111 @TEXT("VCM", size=1, halign="start", valign="baseline") => @PLACE(68.4, -7.3);
// %wire_110 @TEXT("VCM", size=1, halign="end", valign="baseline", rotate=90) => @PLACE(-2.7, -32.4);
// %wire_109 @TEXT("VCM", size=1, halign="start", valign="baseline") => @PLACE(61.4, 11.7);
// %wire_108 @TEXT("VCM", size=1, halign="start", valign="top") => @PLACE(61.4, -27.7);
// %wire_107 @TEXT("VCM", size=1, halign="start", valign="baseline", rotate=90) => @PLACE(25.3, 11.4);
// %wire_112 @TEXT("VCM", size=1, halign="end", valign="baseline", rotate=90) => @PLACE(25.3, -27.4);
// %wire_106 @TEXT("VCM", size=1, halign="end", valign="top", rotate=90) => @PLACE(97.7, 19.3);
// %wire_105 @TEXT("VCM", size=1, halign="start", valign="top", rotate=90) => @PLACE(97.7, -35.3);
// %wire_104 @TEXT("VCM", size=1, halign="start", valign="baseline") => @PLACE(140.4, -6.3);
// %wire_103 @TEXT("VCM", size=1, halign="start", valign="baseline", rotate=90) => @PLACE(96.3, -43.6);
// %wire_102 @TEXT("VCM", size=1, halign="start", valign="baseline") => @PLACE(49.4, 23.7);
// %wire_101 @TEXT("VCM", size=1, halign="start", valign="top") => @PLACE(49.4, -39.7);
// %p84 = (53, -43);
// %wire_115 = &"PHI2" @WIRE(mode="straight") {%p84 #"W19":3};
// %p85 = (53, 27);
// %wire_116 = &"PHI2" @WIRE(mode="straight") {%p85 #"W17":3};
// %p86 = (124, -40);
// %wire_117 = &"PHI2" @WIRE(mode="straight") {#"V7":1 %p86};
// %p87 = (119, -36);
// %wire_118 = &"PHI2" @WIRE(mode="straight") {%p87 #"W15":3};
// %p88 = (119, 20);
// %wire_119 = &"PHI2" @WIRE(mode="straight") {%p88 #"W14":3};
// %p89 = (80, -22);
// %wire_120 = &"PHI2" @WIRE(mode="straight") {%p89 #"W12":3};
// %p90 = (80, 6);
// %wire_121 = &"PHI2" @WIRE(mode="straight") {%p90 #"W4":3};
// %p91 = (-19, -36);
// %wire_122 = &"PHI2" @WIRE(mode="straight") {%p91 #"W3":3};
// %p92 = (-19, 19);
// %wire_123 = &"PHI2" @WIRE(mode="straight") {%p92 #"W2":3};
// %wire_123 @TEXT("PHI2", size=1, halign="start", valign="baseline", rotate=90) => @PLACE(-19.7, 15.4);
// %wire_122 @TEXT("PHI2", size=1, halign="end", valign="baseline", rotate=90) => @PLACE(-19.7, -32.4);
// %wire_121 @TEXT("PHI2", size=1, halign="end", valign="baseline") => @PLACE(83.6, 6.7);
// %wire_120 @TEXT("PHI2", size=1, halign="end", valign="top") => @PLACE(83.6, -22.7);
// %wire_119 @TEXT("PHI2", size=1, halign="start", valign="top", rotate=90) => @PLACE(119.7, 16.4);
// %wire_118 @TEXT("PHI2", size=1, halign="end", valign="top", rotate=90) => @PLACE(119.7, -32.4);
// %wire_117 @TEXT("PHI2", size=1, halign="start", valign="baseline", rotate=90) => @PLACE(123.3, -43.6);
// %wire_116 @TEXT("PHI2", size=1, halign="start", valign="baseline") => @PLACE(49.4, 27.7);
// %wire_115 @TEXT("PHI2", size=1, halign="start", valign="top") => @PLACE(49.4, -43.7);
// %p93 = (115, -40);
// %wire_124 = &"PHI1E" @WIRE(mode="straight") {#"V6":1 %p93};
// %p94 = (65, -31);
// %wire_125 = &"PHI1E" @WIRE(mode="straight") {%p94 #"W8":3};
// %p95 = (65, 15);
// %wire_126 = &"PHI1E" @WIRE(mode="straight") {%p95 #"W7":3};
// %p96 = (-6, -36);
// %wire_127 = &"PHI1E" @WIRE(mode="straight") {%p96 #"W6":3};
// %p97 = (-6, 19);
// %wire_128 = &"PHI1E" @WIRE(mode="straight") {%p97 #"W5":3};
// %wire_128 @TEXT("PHI1E", size=1, halign="start", valign="baseline", rotate=90) => @PLACE(-6.7, 15.4);
// %wire_127 @TEXT("PHI1E", size=1, halign="end", valign="baseline", rotate=90) => @PLACE(-6.7, -32.4);
// %wire_126 @TEXT("PHI1E", size=1, halign="start", valign="baseline") => @PLACE(61.4, 15.7);
// %wire_125 @TEXT("PHI1E", size=1, halign="start", valign="top") => @PLACE(61.4, -31.7);
// %wire_124 @TEXT("PHI1E", size=1, halign="start", valign="baseline", rotate=90) => @PLACE(114.3, -43.6);
// %p98 = (32, -52);
// %wire_129 = &"PHI1" @WIRE(mode="straight") {%p98 #"W18":3};
// %p99 = (106, -40);
// %wire_130 = &"PHI1" @WIRE(mode="straight") {#"V5":1 %p99};
// %p100 = (101, -36);
// %wire_131 = &"PHI1" @WIRE(mode="straight") {%p100 #"W13":3};
// %p101 = (101, 20);
// %wire_132 = &"PHI1" @WIRE(mode="straight") {%p101 #"W11":3};
// %p102 = (22, -31);
// %wire_133 = &"PHI1" @WIRE(mode="straight") {%p102 #"W10":3};
// %p103 = (22, 15);
// %wire_134 = &"PHI1" @WIRE(mode="straight") {%p103 #"W9":3};
// %p104 = (-33, -19);
// %wire_135 = &"PHI1" @WIRE(mode="straight") {%p104 #"W1":3};
// %p105 = (32, 36);
// %wire_136 = &"PHI1" @WIRE(mode="straight") {%p105 #"W16":3};
// %p106 = (-33, 2);
// %wire_137 = &"PHI1" @WIRE(mode="straight") {%p106 #"W0":3};
// %wire_137 @TEXT("PHI1", size=1, halign="end", valign="baseline") => @PLACE(-29.4, 2.7);
// %wire_136 @TEXT("PHI1", size=1, halign="start", valign="baseline", rotate=90) => @PLACE(31.3, 32.4);
// %wire_135 @TEXT("PHI1", size=1, halign="end", valign="top") => @PLACE(-29.4, -19.7);
// %wire_134 @TEXT("PHI1", size=1, halign="start", valign="baseline", rotate=90) => @PLACE(21.3, 11.4);
// %wire_133 @TEXT("PHI1", size=1, halign="end", valign="baseline", rotate=90) => @PLACE(21.3, -27.4);
// %wire_132 @TEXT("PHI1", size=1, halign="start", valign="top", rotate=90) => @PLACE(101.7, 16.4);
// %wire_131 @TEXT("PHI1", size=1, halign="end", valign="top", rotate=90) => @PLACE(101.7, -32.4);
// %wire_130 @TEXT("PHI1", size=1, halign="start", valign="baseline", rotate=90) => @PLACE(105.3, -43.6);
// %wire_129 @TEXT("PHI1", size=1, halign="end", valign="baseline", rotate=90) => @PLACE(31.3, -48.4);
// %wire_138 = &"VOUTP" @WIRE(mode="straight") {#"I2":5 %port_1:p};
// %wire_138 @TEXT("VOUTP", size=1, halign="start", valign="baseline") => @PLACE(140.4, -8.3);
// %wire_139 = &"VOUTN" @WIRE(mode="straight") {#"I2":6 %port_0:p};
// %wire_139 @TEXT("VOUTN", size=1, halign="start", valign="baseline") => @PLACE(140.4, -4.3);
// $JUNCTION @ATTACH %p0;
// $JUNCTION @ATTACH %p1;
// $JUNCTION @ATTACH %p3;
// $JUNCTION @ATTACH %p4;
// $JUNCTION @ATTACH %p5;
// $JUNCTION @ATTACH %p7;
// $JUNCTION @ATTACH %p8;
// $JUNCTION @ATTACH %p10;
// $JUNCTION @ATTACH %p11;
// $JUNCTION @ATTACH %p12;
// $JUNCTION @ATTACH %p14;
// $JUNCTION @ATTACH %p15;
// $JUNCTION @ATTACH %p17;
// $JUNCTION @ATTACH %p18;
// $JUNCTION @ATTACH %p49;
// $JUNCTION @ATTACH %p53
// }
ends tb_Pipeline_Ideal_Model
