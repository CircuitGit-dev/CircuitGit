// Explicit saved-library assembly.
simulator lang=spectre
include "Amplifier_Main.scs"
include "tb_Pipeline_Ideal_Model.scs"
