// Explicit saved-library assembly.
simulator lang=spectre
include "Switch.scs"
