// Explicit saved-library assembly.
simulator lang=spectre
include "PIPE_OTA_Diff_Ideal.scs"
