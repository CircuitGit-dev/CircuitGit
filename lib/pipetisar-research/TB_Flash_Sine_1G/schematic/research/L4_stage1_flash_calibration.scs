// @RNL(type="header") {
// @VERSION("0.3");
// @USE-PACKAGE(name="rnl-std-spectre", version="0.3", path="rnl-std-spectre.rnl");
// @USE-PACKAGE(name="eda-symbol", version="0.1", path="eda-symbol.rnl");
// @USE-PACKAGE(name="eda-style", version="0.1", path="eda-style.rnl")
// }
// Design: 2026_PIPETISAR_RESEARCH/L4_stage1_flash_calibration
simulator lang=spectre
global 0

// tsmcN28/trans_ulvt_mac/schematic

// 2026_PIPETISAR_RESEARCH/L5_stage1_flash_cal_mux/schematic

// 2026_PIPETISAR_RESEARCH/L4_stage1_flash_calibration/schematic
subckt L4_stage1_flash_calibration SLCT_55 SLCT_54 SLCT_53 SLCT_52 SLCT_51 SLCT_50 SLCT_49 SLCT_48 SLCT_47 SLCT_46 SLCT_45 SLCT_44 SLCT_43 SLCT_42 SLCT_41 SLCT_40 SLCT_39 SLCT_38 SLCT_37 SLCT_36 SLCT_35 SLCT_34 SLCT_33 SLCT_32 SLCT_31 SLCT_30 SLCT_29 SLCT_28 SLCT_27 SLCT_26 SLCT_25 SLCT_24 SLCT_23 SLCT_22 SLCT_21 SLCT_20 SLCT_19 SLCT_18 SLCT_17 SLCT_16 SLCT_15 SLCT_14 SLCT_13 SLCT_12 SLCT_11 SLCT_10 SLCT_9 SLCT_8 SLCT_7 SLCT_6 SLCT_5 SLCT_4 SLCT_3 SLCT_2 SLCT_1 SLCT_0 VDD VIN_6 VIN_5 VIN_4 VIN_3 VIN_2 VIN_1 VIN_0 VOUTN_7 VOUTN_6 VOUTN_5 VOUTN_4 VOUTN_3 VOUTN_2 VOUTN_1 VOUTN_0 VOUTP_7 VOUTP_6 VOUTP_5 VOUTP_4 VOUTP_3 VOUTP_2 VOUTP_1 VOUTP_0 VSS
    I0_7 (SLCT_55 SLCT_54 SLCT_53 SLCT_52 SLCT_51 SLCT_50 SLCT_49 VDD VIN_6 VIN_5 VIN_4 VIN_3 VIN_2 VIN_1 VIN_0 VOUTN_7 VOUTP_7 VSS) L5_stage1_flash_cal_mux
    I0_6 (SLCT_48 SLCT_47 SLCT_46 SLCT_45 SLCT_44 SLCT_43 SLCT_42 VDD VIN_6 VIN_5 VIN_4 VIN_3 VIN_2 VIN_1 VIN_0 VOUTN_6 VOUTP_6 VSS) L5_stage1_flash_cal_mux
    I0_5 (SLCT_41 SLCT_40 SLCT_39 SLCT_38 SLCT_37 SLCT_36 SLCT_35 VDD VIN_6 VIN_5 VIN_4 VIN_3 VIN_2 VIN_1 VIN_0 VOUTN_5 VOUTP_5 VSS) L5_stage1_flash_cal_mux
    I0_4 (SLCT_34 SLCT_33 SLCT_32 SLCT_31 SLCT_30 SLCT_29 SLCT_28 VDD VIN_6 VIN_5 VIN_4 VIN_3 VIN_2 VIN_1 VIN_0 VOUTN_4 VOUTP_4 VSS) L5_stage1_flash_cal_mux
    I0_3 (SLCT_27 SLCT_26 SLCT_25 SLCT_24 SLCT_23 SLCT_22 SLCT_21 VDD VIN_6 VIN_5 VIN_4 VIN_3 VIN_2 VIN_1 VIN_0 VOUTN_3 VOUTP_3 VSS) L5_stage1_flash_cal_mux
    I0_2 (SLCT_20 SLCT_19 SLCT_18 SLCT_17 SLCT_16 SLCT_15 SLCT_14 VDD VIN_6 VIN_5 VIN_4 VIN_3 VIN_2 VIN_1 VIN_0 VOUTN_2 VOUTP_2 VSS) L5_stage1_flash_cal_mux
    I0_1 (SLCT_13 SLCT_12 SLCT_11 SLCT_10 SLCT_9 SLCT_8 SLCT_7 VDD VIN_6 VIN_5 VIN_4 VIN_3 VIN_2 VIN_1 VIN_0 VOUTN_1 VOUTP_1 VSS) L5_stage1_flash_cal_mux
    I0_0 (SLCT_6 SLCT_5 SLCT_4 SLCT_3 SLCT_2 SLCT_1 SLCT_0 VDD VIN_6 VIN_5 VIN_4 VIN_3 VIN_2 VIN_1 VIN_0 VOUTN_0 VOUTP_0 VSS) L5_stage1_flash_cal_mux
// @RNL(author="rnl-virtuoso") {
// %block_symbol = @DEFINE-SYMBOL(box=[4, -6, 34, 6]) {
// @LINE {(2, -2) (6, -2)};
// @LINE {(2, 0) (6, 0)};
// @LINE {(36, 0) (32, 0)};
// @LINE {(36, -2) (32, -2)};
// @LINE {(20, -10) (20, -6)};
// @LINE {(18, -10) (18, -6)};
// @RECTANGLE {(6, -6) (32, 4)};
// ? @TEXT("${name}", size=1, halign="start", valign="middle", key="name") => @PLACE(30, 5);
// ? @TEXT("${model}", size=1, halign="middle", valign="middle", key="model") => @PLACE(34.5, 3);
// (2, 0) @PIN(terminal=["SLCT_55", "SLCT_54", "SLCT_53", "SLCT_52", "SLCT_51", "SLCT_50", "SLCT_49", "SLCT_48", "SLCT_47", "SLCT_46", "SLCT_45", "SLCT_44", "SLCT_43", "SLCT_42", "SLCT_41", "SLCT_40", "SLCT_39", "SLCT_38", "SLCT_37", "SLCT_36", "SLCT_35", "SLCT_34", "SLCT_33", "SLCT_32", "SLCT_31", "SLCT_30", "SLCT_29", "SLCT_28", "SLCT_27", "SLCT_26", "SLCT_25", "SLCT_24", "SLCT_23", "SLCT_22", "SLCT_21", "SLCT_20", "SLCT_19", "SLCT_18", "SLCT_17", "SLCT_16", "SLCT_15", "SLCT_14", "SLCT_13", "SLCT_12", "SLCT_11", "SLCT_10", "SLCT_9", "SLCT_8", "SLCT_7", "SLCT_6", "SLCT_5", "SLCT_4", "SLCT_3", "SLCT_2", "SLCT_1", "SLCT_0"]);
// (6.6, 0) @TEXT("SLCT<55:0>", size=1, halign="start", valign="middle");
// (2, -2) @PIN(terminal=["VIN_6", "VIN_5", "VIN_4", "VIN_3", "VIN_2", "VIN_1", "VIN_0"]);
// (6.6, -2) @TEXT("VIN<6:0>", size=1, halign="start", valign="middle");
// (36, 0) @PIN(terminal=["VOUTP_7", "VOUTP_6", "VOUTP_5", "VOUTP_4", "VOUTP_3", "VOUTP_2", "VOUTP_1", "VOUTP_0"]);
// (31.4, 0) @TEXT("VOUTP<7:0>", size=1, halign="end", valign="middle");
// (36, -2) @PIN(terminal=["VOUTN_7", "VOUTN_6", "VOUTN_5", "VOUTN_4", "VOUTN_3", "VOUTN_2", "VOUTN_1", "VOUTN_0"]);
// (31.4, -2) @TEXT("VOUTN<7:0>", size=1, halign="end", valign="middle");
// (20, -10) @PIN(terminal="VSS");
// (20, -5.4) @TEXT("VSS", size=1, halign="start", valign="middle", rotate=90);
// (18, -10) @PIN(terminal="VDD");
// (18, -5.4) @TEXT("VDD", size=1, halign="start", valign="middle", rotate=90)
// };
// # @SET-SYMBOL %block_symbol;
// %bundle_0 = {#"I0_7" #"I0_6" #"I0_5" #"I0_4" #"I0_3" #"I0_2" #"I0_1" #"I0_0"} @BUNDLE;
// %bundle_0 @PLACE(84, 16) => @ORIENT("R0");
// %bundle_0 @TEXT("I0<7:0>", key="name");
// %output_port_symbol = @DEFINE-SYMBOL(box=[0, -1, 2, 1]) {
// @LINE(fill="linecolor", linestyle="none") {(0, -0.9) (0, 0.9) (1.1, 0.9) (2, 0) (1.1, -0.9) (0, -0.9)};
// (0, 0) @PIN(terminal=1, direction="left");
// ? @TEXT("${name}", key="name", halign="middle") => @PLACE(1, 1.6)
// };
// %bus_port_type_0 = @DEFINE(roles=[["p", "net"], ["p1", "net"], ["p2", "net"], ["p3", "net"], ["p4", "net"], ["p5", "net"], ["p6", "net"], ["p7", "net"]]) {};
// %bus_port_type_0_symbol = @DEFINE-SYMBOL {(0, 0) @PIN(terminal=[1, 2, 3, 4, 5, 6, 7, 8])};
// {&"VOUTN_7" &"VOUTN_6" &"VOUTN_5" &"VOUTN_4" &"VOUTN_3" &"VOUTN_2" &"VOUTN_1" &"VOUTN_0"} @REMOVE-FROM $PORT_FILL_SET;
// %port_0 = %bus_port_type_0 @ATTACH &"VOUTN_7" &"VOUTN_6" &"VOUTN_5" &"VOUTN_4" &"VOUTN_3" &"VOUTN_2" &"VOUTN_1" &"VOUTN_0" => @PLACE(114, 15) => @ORIENT("R0");
// %port_0 @SET-SYMBOL %bus_port_type_0_symbol;
// %port_0_marker = $IO_PORT @ATTACH &"VOUTN_7" => @PLACE(114, 15) => @ORIENT("R0");
// %port_0_marker @SET-SYMBOL %output_port_symbol;
// %port_0_marker @TEXT("VOUTN<7:0>", key="name");
// %input_port_symbol = @DEFINE-SYMBOL(box=[-2, -1, 0, 1]) {
// @LINE(fill="linecolor", linestyle="none") {(-2, -0.9) (-2, 0.9) (-0.9, 0.9) (0, 0) (-0.9, -0.9) (-2, -0.9)};
// (0, 0) @PIN(terminal=1, direction="right");
// ? @TEXT("${name}", key="name", halign="middle") => @PLACE(-1, 1.6)
// };
// %bus_port_type_1 = @DEFINE(roles=[["p", "net"], ["p1", "net"], ["p2", "net"], ["p3", "net"], ["p4", "net"], ["p5", "net"], ["p6", "net"]]) {};
// %bus_port_type_1_symbol = @DEFINE-SYMBOL {(0, 0) @PIN(terminal=[1, 2, 3, 4, 5, 6, 7])};
// {&"VIN_6" &"VIN_5" &"VIN_4" &"VIN_3" &"VIN_2" &"VIN_1" &"VIN_0"} @REMOVE-FROM $PORT_FILL_SET;
// %port_1 = %bus_port_type_1 @ATTACH &"VIN_6" &"VIN_5" &"VIN_4" &"VIN_3" &"VIN_2" &"VIN_1" &"VIN_0" => @PLACE(78, 15) => @ORIENT("R0");
// %port_1 @SET-SYMBOL %bus_port_type_1_symbol;
// %port_1_marker = $IO_PORT @ATTACH &"VIN_6" => @PLACE(78, 15) => @ORIENT("R0");
// %port_1_marker @SET-SYMBOL %input_port_symbol;
// %port_1_marker @TEXT("VIN<6:0>", key="name");
// %port_2 = $IO_PORT @ATTACH &"VDD" => @PLACE(95, -1) => @ORIENT("R90");
// %port_3 = $IO_PORT @ATTACH &"VSS" => @PLACE(97, -1) => @ORIENT("R90");
// %bus_port_type_4 = @DEFINE(roles=[["p", "net"], ["p1", "net"], ["p2", "net"], ["p3", "net"], ["p4", "net"], ["p5", "net"], ["p6", "net"], ["p7", "net"]]) {};
// %bus_port_type_4_symbol = @DEFINE-SYMBOL {(0, 0) @PIN(terminal=[1, 2, 3, 4, 5, 6, 7, 8])};
// {&"VOUTP_7" &"VOUTP_6" &"VOUTP_5" &"VOUTP_4" &"VOUTP_3" &"VOUTP_2" &"VOUTP_1" &"VOUTP_0"} @REMOVE-FROM $PORT_FILL_SET;
// %port_4 = %bus_port_type_4 @ATTACH &"VOUTP_7" &"VOUTP_6" &"VOUTP_5" &"VOUTP_4" &"VOUTP_3" &"VOUTP_2" &"VOUTP_1" &"VOUTP_0" => @PLACE(114, 17) => @ORIENT("R0");
// %port_4 @SET-SYMBOL %bus_port_type_4_symbol;
// %port_4_marker = $IO_PORT @ATTACH &"VOUTP_7" => @PLACE(114, 17) => @ORIENT("R0");
// %port_4_marker @SET-SYMBOL %output_port_symbol;
// %port_4_marker @TEXT("VOUTP<7:0>", key="name");
// %bus_port_type_5 = @DEFINE(roles=[["p", "net"], ["p1", "net"], ["p2", "net"], ["p3", "net"], ["p4", "net"], ["p5", "net"], ["p6", "net"], ["p7", "net"], ["p8", "net"], ["p9", "net"], ["p10", "net"], ["p11", "net"], ["p12", "net"], ["p13", "net"], ["p14", "net"], ["p15", "net"], ["p16", "net"], ["p17", "net"], ["p18", "net"], ["p19", "net"], ["p20", "net"], ["p21", "net"], ["p22", "net"], ["p23", "net"], ["p24", "net"], ["p25", "net"], ["p26", "net"], ["p27", "net"], ["p28", "net"], ["p29", "net"], ["p30", "net"], ["p31", "net"], ["p32", "net"], ["p33", "net"], ["p34", "net"], ["p35", "net"], ["p36", "net"], ["p37", "net"], ["p38", "net"], ["p39", "net"], ["p40", "net"], ["p41", "net"], ["p42", "net"], ["p43", "net"], ["p44", "net"], ["p45", "net"], ["p46", "net"], ["p47", "net"], ["p48", "net"], ["p49", "net"], ["p50", "net"], ["p51", "net"], ["p52", "net"], ["p53", "net"], ["p54", "net"], ["p55", "net"]]) {};
// %bus_port_type_5_symbol = @DEFINE-SYMBOL {(0, 0) @PIN(terminal=[1, 2, 3, 4, 5, 6, 7, 8, 9, 10, 11, 12, 13, 14, 15, 16, 17, 18, 19, 20, 21, 22, 23, 24, 25, 26, 27, 28, 29, 30, 31, 32, 33, 34, 35, 36, 37, 38, 39, 40, 41, 42, 43, 44, 45, 46, 47, 48, 49, 50, 51, 52, 53, 54, 55, 56])};
// {&"SLCT_55" &"SLCT_54" &"SLCT_53" &"SLCT_52" &"SLCT_51" &"SLCT_50" &"SLCT_49" &"SLCT_48" &"SLCT_47" &"SLCT_46" &"SLCT_45" &"SLCT_44" &"SLCT_43" &"SLCT_42" &"SLCT_41" &"SLCT_40" &"SLCT_39" &"SLCT_38" &"SLCT_37" &"SLCT_36" &"SLCT_35" &"SLCT_34" &"SLCT_33" &"SLCT_32" &"SLCT_31" &"SLCT_30" &"SLCT_29" &"SLCT_28" &"SLCT_27" &"SLCT_26" &"SLCT_25" &"SLCT_24" &"SLCT_23" &"SLCT_22" &"SLCT_21" &"SLCT_20" &"SLCT_19" &"SLCT_18" &"SLCT_17" &"SLCT_16" &"SLCT_15" &"SLCT_14" &"SLCT_13" &"SLCT_12" &"SLCT_11" &"SLCT_10" &"SLCT_9" &"SLCT_8" &"SLCT_7" &"SLCT_6" &"SLCT_5" &"SLCT_4" &"SLCT_3" &"SLCT_2" &"SLCT_1" &"SLCT_0"} @REMOVE-FROM $PORT_FILL_SET;
// %port_5 = %bus_port_type_5 @ATTACH &"SLCT_55" &"SLCT_54" &"SLCT_53" &"SLCT_52" &"SLCT_51" &"SLCT_50" &"SLCT_49" &"SLCT_48" &"SLCT_47" &"SLCT_46" &"SLCT_45" &"SLCT_44" &"SLCT_43" &"SLCT_42" &"SLCT_41" &"SLCT_40" &"SLCT_39" &"SLCT_38" &"SLCT_37" &"SLCT_36" &"SLCT_35" &"SLCT_34" &"SLCT_33" &"SLCT_32" &"SLCT_31" &"SLCT_30" &"SLCT_29" &"SLCT_28" &"SLCT_27" &"SLCT_26" &"SLCT_25" &"SLCT_24" &"SLCT_23" &"SLCT_22" &"SLCT_21" &"SLCT_20" &"SLCT_19" &"SLCT_18" &"SLCT_17" &"SLCT_16" &"SLCT_15" &"SLCT_14" &"SLCT_13" &"SLCT_12" &"SLCT_11" &"SLCT_10" &"SLCT_9" &"SLCT_8" &"SLCT_7" &"SLCT_6" &"SLCT_5" &"SLCT_4" &"SLCT_3" &"SLCT_2" &"SLCT_1" &"SLCT_0" => @PLACE(78, 17) => @ORIENT("R0");
// %port_5 @SET-SYMBOL %bus_port_type_5_symbol;
// %port_5_marker = $IO_PORT @ATTACH &"SLCT_55" => @PLACE(78, 17) => @ORIENT("R0");
// %port_5_marker @SET-SYMBOL %input_port_symbol;
// %port_5_marker @TEXT("SLCT<55:0>", key="name");
// %wire_0 = {&"VOUTP_7" &"VOUTP_6" &"VOUTP_5" &"VOUTP_4" &"VOUTP_3" &"VOUTP_2" &"VOUTP_1" &"VOUTP_0"} @WIRE(mode="straight") {%bundle_0:17 %port_4:1};
// %wire_1 = {&"SLCT_55" &"SLCT_54" &"SLCT_53" &"SLCT_52" &"SLCT_51" &"SLCT_50" &"SLCT_49" &"SLCT_48" &"SLCT_47" &"SLCT_46" &"SLCT_45" &"SLCT_44" &"SLCT_43" &"SLCT_42" &"SLCT_41" &"SLCT_40" &"SLCT_39" &"SLCT_38" &"SLCT_37" &"SLCT_36" &"SLCT_35" &"SLCT_34" &"SLCT_33" &"SLCT_32" &"SLCT_31" &"SLCT_30" &"SLCT_29" &"SLCT_28" &"SLCT_27" &"SLCT_26" &"SLCT_25" &"SLCT_24" &"SLCT_23" &"SLCT_22" &"SLCT_21" &"SLCT_20" &"SLCT_19" &"SLCT_18" &"SLCT_17" &"SLCT_16" &"SLCT_15" &"SLCT_14" &"SLCT_13" &"SLCT_12" &"SLCT_11" &"SLCT_10" &"SLCT_9" &"SLCT_8" &"SLCT_7" &"SLCT_6" &"SLCT_5" &"SLCT_4" &"SLCT_3" &"SLCT_2" &"SLCT_1" &"SLCT_0"} @WIRE(mode="straight") {%port_5:1 %bundle_0:1};
// %p0 = (77, 17);
// %wire_2 = {&"SLCT_55" &"SLCT_54" &"SLCT_53" &"SLCT_52" &"SLCT_51" &"SLCT_50" &"SLCT_49" &"SLCT_48" &"SLCT_47" &"SLCT_46" &"SLCT_45" &"SLCT_44" &"SLCT_43" &"SLCT_42" &"SLCT_41" &"SLCT_40" &"SLCT_39" &"SLCT_38" &"SLCT_37" &"SLCT_36" &"SLCT_35" &"SLCT_34" &"SLCT_33" &"SLCT_32" &"SLCT_31" &"SLCT_30" &"SLCT_29" &"SLCT_28" &"SLCT_27" &"SLCT_26" &"SLCT_25" &"SLCT_24" &"SLCT_23" &"SLCT_22" &"SLCT_21" &"SLCT_20" &"SLCT_19" &"SLCT_18" &"SLCT_17" &"SLCT_16" &"SLCT_15" &"SLCT_14" &"SLCT_13" &"SLCT_12" &"SLCT_11" &"SLCT_10" &"SLCT_9" &"SLCT_8" &"SLCT_7" &"SLCT_6" &"SLCT_5" &"SLCT_4" &"SLCT_3" &"SLCT_2" &"SLCT_1" &"SLCT_0"} @WIRE(mode="straight") {%p0 %port_5:1};
// %wire_3 = {&"VIN_6" &"VIN_5" &"VIN_4" &"VIN_3" &"VIN_2" &"VIN_1" &"VIN_0"} @WIRE(mode="straight") {%port_1:1 %bundle_0:9};
// %wire_4 = {&"VOUTN_7" &"VOUTN_6" &"VOUTN_5" &"VOUTN_4" &"VOUTN_3" &"VOUTN_2" &"VOUTN_1" &"VOUTN_0"} @WIRE(mode="straight") {%bundle_0:16 %port_0:1};
// %p1 = (97, 0);
// %wire_5 = &"VSS" @WIRE(mode="straight") {%p1 %bundle_0:18};
// %p2 = (95, 0);
// %wire_6 = &"VDD" @WIRE(mode="straight") {%p2 %bundle_0:8}
// }
ends L4_stage1_flash_calibration
