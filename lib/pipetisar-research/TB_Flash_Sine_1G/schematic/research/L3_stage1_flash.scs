// @RNL(type="header") {
// @VERSION("0.3");
// @USE-PACKAGE(name="rnl-std-spectre", version="0.3", path="rnl-std-spectre.rnl");
// @USE-PACKAGE(name="eda-symbol", version="0.1", path="eda-symbol.rnl");
// @USE-PACKAGE(name="eda-style", version="0.1", path="eda-style.rnl")
// }
// Design: 2026_PIPETISAR_RESEARCH/L3_stage1_flash
simulator lang=spectre
global 0

// tcbn28hpcplusbwp12t30p140ulvt/ND2D0BWP12T30P140ULVT/schematic

// tsmcN28/trans_ulvt_mac/schematic

// 2026_PIPETISAR_RESEARCH/L4_stage1_flash_comparator/schematic

// 2026_PIPETISAR_RESEARCH/L4_stage1_flash_bootstrapper/schematic

// 2026_PIPETISAR_RESEARCH/L4_stage1_flash_rdac/schematic

// 2026_PIPETISAR_RESEARCH/L4_stage1_flash_clkbooster/schematic

// 2026_PIPETISAR_RESEARCH/L5_stage1_flash_cal_mux/schematic

// 2026_PIPETISAR_RESEARCH/L4_stage1_flash_calibration/schematic

// 2026_PIPETISAR_RESEARCH/L3_stage1_flash/schematic
subckt L3_stage1_flash D_7 D_6 D_5 D_4 D_3 D_2 D_1 D_0 DN_7 DN_6 DN_5 DN_4 DN_3 DN_2 DN_1 DN_0 DP_7 DP_6 DP_5 DP_4 DP_3 DP_2 DP_1 DP_0 IB PHI1EN PHI1N PHI2N PHI2P SLCT_55 SLCT_54 SLCT_53 SLCT_52 SLCT_51 SLCT_50 SLCT_49 SLCT_48 SLCT_47 SLCT_46 SLCT_45 SLCT_44 SLCT_43 SLCT_42 SLCT_41 SLCT_40 SLCT_39 SLCT_38 SLCT_37 SLCT_36 SLCT_35 SLCT_34 SLCT_33 SLCT_32 SLCT_31 SLCT_30 SLCT_29 SLCT_28 SLCT_27 SLCT_26 SLCT_25 SLCT_24 SLCT_23 SLCT_22 SLCT_21 SLCT_20 SLCT_19 SLCT_18 SLCT_17 SLCT_16 SLCT_15 SLCT_14 SLCT_13 SLCT_12 SLCT_11 SLCT_10 SLCT_9 SLCT_8 SLCT_7 SLCT_6 SLCT_5 SLCT_4 SLCT_3 SLCT_2 SLCT_1 SLCT_0 VCM VDD VINN VINP VREFN VREFP VSS
    I0_7 (D_7 DN_7 DP_7 PHI1BSTN PHI1BSTP PHI1ENBUF PHI1EPBUF PHI1EPBST PHI2N PHI2P IB VCM VDD VINN VINP VOSN_7 VOSP_7 VREF_0 VREF_7 VSS) L4_stage1_flash_comparator
    I0_6 (D_6 DN_6 DP_6 PHI1BSTN PHI1BSTP PHI1ENBUF PHI1EPBUF PHI1EPBST PHI2N PHI2P IB VCM VDD VINN VINP VOSN_6 VOSP_6 VREF_1 VREF_6 VSS) L4_stage1_flash_comparator
    I0_5 (D_5 DN_5 DP_5 PHI1BSTN PHI1BSTP PHI1ENBUF PHI1EPBUF PHI1EPBST PHI2N PHI2P IB VCM VDD VINN VINP VOSN_5 VOSP_5 VREF_2 VREF_5 VSS) L4_stage1_flash_comparator
    I0_4 (D_4 DN_4 DP_4 PHI1BSTN PHI1BSTP PHI1ENBUF PHI1EPBUF PHI1EPBST PHI2N PHI2P IB VCM VDD VINN VINP VOSN_4 VOSP_4 VREF_3 VREF_4 VSS) L4_stage1_flash_comparator
    I0_3 (D_3 DN_3 DP_3 PHI1BSTN PHI1BSTP PHI1ENBUF PHI1EPBUF PHI1EPBST PHI2N PHI2P IB VCM VDD VINN VINP VOSN_3 VOSP_3 VREF_4 VREF_3 VSS) L4_stage1_flash_comparator
    I0_2 (D_2 DN_2 DP_2 PHI1BSTN PHI1BSTP PHI1ENBUF PHI1EPBUF PHI1EPBST PHI2N PHI2P IB VCM VDD VINN VINP VOSN_2 VOSP_2 VREF_5 VREF_2 VSS) L4_stage1_flash_comparator
    I0_1 (D_1 DN_1 DP_1 PHI1BSTN PHI1BSTP PHI1ENBUF PHI1EPBUF PHI1EPBST PHI2N PHI2P IB VCM VDD VINN VINP VOSN_1 VOSP_1 VREF_6 VREF_1 VSS) L4_stage1_flash_comparator
    I0_0 (D_0 DN_0 DP_0 PHI1BSTN PHI1BSTP PHI1ENBUF PHI1EPBUF PHI1EPBST PHI2N PHI2P IB VCM VDD VINN VINP VOSN_0 VOSP_0 VREF_7 VREF_0 VSS) L4_stage1_flash_comparator
    I1 (PHI1N PHI1BSTN PHI1BSTP VDD VINN VINP VSS) L4_stage1_flash_bootstrapper
    M1 (VSS IB VSS VSS) nch_mac l=90n w=500n multi=2 nf=1
    M24 (net23 IB VSS VSS) nch_mac l=90n w=500n multi=8 nf=1
    I2 (VOSREF_2 VOSREF_1 VOSREF_0 VREF_7 VREF_6 VREF_5 VREF_4 VREF_3 VREF_2 VREF_1 VREF_0 VREFN VREFP) L4_stage1_flash_rdac
    I4 (PHI1EN PHI1ENBUF PHI1EPBST PHI1EPBUF VDD VSS) L4_stage1_flash_clkbooster
    C0 (IB VSS) cfmom_2t nr=24 lr=2u w=50n s=50n stm=1 spm=7 multi=1
    M0 (IB VCM net23 VSS) nch_ulvt_mac l=30n w=9u multi=1 nf=18
    I5 (SLCT_55 SLCT_54 SLCT_53 SLCT_52 SLCT_51 SLCT_50 SLCT_49 SLCT_48 SLCT_47 SLCT_46 SLCT_45 SLCT_44 SLCT_43 SLCT_42 SLCT_41 SLCT_40 SLCT_39 SLCT_38 SLCT_37 SLCT_36 SLCT_35 SLCT_34 SLCT_33 SLCT_32 SLCT_31 SLCT_30 SLCT_29 SLCT_28 SLCT_27 SLCT_26 SLCT_25 SLCT_24 SLCT_23 SLCT_22 SLCT_21 SLCT_20 SLCT_19 SLCT_18 SLCT_17 SLCT_16 SLCT_15 SLCT_14 SLCT_13 SLCT_12 SLCT_11 SLCT_10 SLCT_9 SLCT_8 SLCT_7 SLCT_6 SLCT_5 SLCT_4 SLCT_3 SLCT_2 SLCT_1 SLCT_0 VDD VREF_5 VOSREF_2 VREF_4 VOSREF_1 VREF_3 VOSREF_0 VREF_2 VOSN_7 VOSN_6 VOSN_5 VOSN_4 VOSN_3 VOSN_2 VOSN_1 VOSN_0 VOSP_7 VOSP_6 VOSP_5 VOSP_4 VOSP_3 VOSP_2 VOSP_1 VOSP_0 VSS) L4_stage1_flash_calibration
// @RNL(author="rnl-virtuoso") {
// %block_symbol = @DEFINE-SYMBOL(box=[1, -10, 31, 10]) {
// @LINE {(18, 12) (18, 8)};
// @LINE {(10, 12) (10, 8)};
// @LINE {(12, 12) (12, 8)};
// @LINE {(14, 12) (14, 8)};
// @LINE {(16, 12) (16, 8)};
// @LINE {(3, 8) (29, 8) (29, -8) (3, -8) (3, 8)};
// @LINE {(33, 2) (29, 2)};
// @LINE {(33, -2) (29, -2)};
// @LINE {(33, 0) (29, 0)};
// @LINE {(20, 12) (20, 8)};
// @LINE {(22, 12) (22, 8)};
// @LINE {(-1, 1) (3, 1)};
// @LINE {(-1, -1) (3, -1)};
// @LINE {(13, -12) (13, -8)};
// @LINE {(15, -12) (15, -8)};
// @LINE {(17, -12) (17, -8)};
// @LINE {(19, -12) (19, -8)};
// @LINE {(10, 0) (13, 3) (20, 3) (20, -3) (13, -3) (10, 0)};
// ? @TEXT("${name}", size=1, halign="start", valign="middle", key="name") => @PLACE(27, 9);
// ? @TEXT("${model}", size=1, halign="middle", valign="middle", key="model") => @PLACE(32, 7);
// (-1, 1) @PIN(terminal="VINP");
// (3.6, 1) @TEXT("VINP", size=1, halign="start", valign="middle");
// (-1, -1) @PIN(terminal="VINN");
// (3.6, -1) @TEXT("VINN", size=1, halign="start", valign="middle");
// (16, 12) @PIN(terminal="PHI2P");
// (16, 7.4) @TEXT("PHI2P", size=1, halign="end", valign="middle", rotate=90);
// (18, 12) @PIN(terminal="PHI2N");
// (18, 7.4) @TEXT("PHI2N", size=1, halign="end", valign="middle", rotate=90);
// (12, 12) @PIN(terminal="PHI1N");
// (12, 7.4) @TEXT("PHI1N", size=1, halign="end", valign="middle", rotate=90);
// (14, 12) @PIN(terminal="PHI1EN");
// (14, 7.4) @TEXT("PHI1EN", size=1, halign="end", valign="middle", rotate=90);
// (22, 12) @PIN(terminal="IB");
// (22, 7.4) @TEXT("IB", size=1, halign="end", valign="middle", rotate=90);
// (33, 0) @PIN(terminal=["DP_7", "DP_6", "DP_5", "DP_4", "DP_3", "DP_2", "DP_1", "DP_0"]);
// (28.4, 0) @TEXT("DP<7:0>", size=1, halign="end", valign="middle");
// (33, -2) @PIN(terminal=["DN_7", "DN_6", "DN_5", "DN_4", "DN_3", "DN_2", "DN_1", "DN_0"]);
// (28.4, -2) @TEXT("DN<7:0>", size=1, halign="end", valign="middle");
// (33, 2) @PIN(terminal=["D_7", "D_6", "D_5", "D_4", "D_3", "D_2", "D_1", "D_0"]);
// (28.4, 2) @TEXT("D<7:0>", size=1, halign="end", valign="middle");
// (19, -12) @PIN(terminal="VSS");
// (19, -7.4) @TEXT("VSS", size=1, halign="start", valign="middle", rotate=90);
// (13, -12) @PIN(terminal="VREFP");
// (13, -7.4) @TEXT("VREFP", size=1, halign="start", valign="middle", rotate=90);
// (15, -12) @PIN(terminal="VREFN");
// (15, -7.4) @TEXT("VREFN", size=1, halign="start", valign="middle", rotate=90);
// (17, -12) @PIN(terminal="VDD");
// (17, -7.4) @TEXT("VDD", size=1, halign="start", valign="middle", rotate=90);
// (10, 12) @PIN(terminal="VCM");
// (10, 7.4) @TEXT("VCM", size=1, halign="end", valign="middle", rotate=90);
// (20, 12) @PIN(terminal=["SLCT_55", "SLCT_54", "SLCT_53", "SLCT_52", "SLCT_51", "SLCT_50", "SLCT_49", "SLCT_48", "SLCT_47", "SLCT_46", "SLCT_45", "SLCT_44", "SLCT_43", "SLCT_42", "SLCT_41", "SLCT_40", "SLCT_39", "SLCT_38", "SLCT_37", "SLCT_36", "SLCT_35", "SLCT_34", "SLCT_33", "SLCT_32", "SLCT_31", "SLCT_30", "SLCT_29", "SLCT_28", "SLCT_27", "SLCT_26", "SLCT_25", "SLCT_24", "SLCT_23", "SLCT_22", "SLCT_21", "SLCT_20", "SLCT_19", "SLCT_18", "SLCT_17", "SLCT_16", "SLCT_15", "SLCT_14", "SLCT_13", "SLCT_12", "SLCT_11", "SLCT_10", "SLCT_9", "SLCT_8", "SLCT_7", "SLCT_6", "SLCT_5", "SLCT_4", "SLCT_3", "SLCT_2", "SLCT_1", "SLCT_0"]);
// (20, 7.4) @TEXT("SLCT<55:0>", size=1, halign="end", valign="middle", rotate=90)
// };
// # @SET-SYMBOL %block_symbol;
// %symbol_0 = @DEFINE-SYMBOL(box=[-0.1, -2.8, 3.8, 2.8]) {
// @LINE {(2, 1.5) (4, 1.5) (4, 3)};
// @LINE {(2, -1.5) (2, 1.5)};
// @LINE {(3, -1) (4, -1.5) (3, -2)};
// @LINE {(0, 0) (1.5, 0)};
// @LINE {(1.5, 1.5) (1.5, -1.5)};
// @LINE {(2, -1.5) (4, -1.5) (4, -3)};
// ? @TEXT("${name}", size=0.8, halign="start", valign="baseline", key="name") => @PLACE(5, 3.5);
// ? @TEXT("${model}", size=0.8, halign="end", valign="baseline", key="model") => @PLACE(3.2, 3.2);
// (4, -1) @PIN(terminal=4);
// (4, -3) @PIN(terminal=3);
// (4, 3) @PIN(terminal=1);
// (0, 0) @PIN(terminal=2)
// };
// #"M1" @SET-SYMBOL %symbol_0;
// #"M1" @PLACE(-72, 4) => @ORIENT("MYR90");
// %symbol_1 = @DEFINE-SYMBOL(box=[-2, -6, 2, 0]) {
// @LINE {(1, -2.2) (-1, -2.2)};
// @LINE {(0, 0) (0, -2.2)};
// @LINE {(0, -2.8) (0, -6)};
// @ARC {(1, -3.2) (0, -2.8) (-1, -3.2)};
// ? @TEXT("${name}", size=0.8, halign="start", valign="baseline", key="name") => @PLACE(1.4, 0.1);
// ? @TEXT("${model}", size=0.8, halign="end", valign="baseline", key="model") => @PLACE(-1.1, 0.3);
// (0, 0) @PIN(terminal=1);
// (0, -6) @PIN(terminal=2)
// };
// #"C0" @SET-SYMBOL %symbol_1;
// #"C0" @PLACE(-64, 11) => @ORIENT("R0");
// %symbol_2 = @DEFINE-SYMBOL(box=[-0.1, -2.8, 3.8, 2.8]) {
// @LINE {(2, 1.5) (4, 1.5) (4, 3)};
// @LINE {(2, -1.5) (2, 1.5)};
// @LINE {(3, -1) (4, -1.5) (3, -2)};
// @LINE {(0, 0) (1.5, 0)};
// @LINE {(1.5, 1.5) (1.5, -1.5)};
// @LINE {(2, -1.5) (4, -1.5) (4, -3)};
// ? @TEXT("${name}", size=0.8, halign="start", valign="baseline", key="name") => @PLACE(5, 3.5);
// ? @TEXT("${model}", size=0.8, halign="end", valign="baseline", key="model") => @PLACE(3.2, 3.2);
// (4, -1) @PIN(terminal=4);
// (4, -3) @PIN(terminal=3);
// (4, 3) @PIN(terminal=1);
// (0, 0) @PIN(terminal=2)
// };
// #"M0" @SET-SYMBOL %symbol_2;
// #"M0" @PLACE(-84, 24) => @ORIENT("R0");
// #"I5" @PLACE(-81, -31) => @ORIENT("R0");
// %bundle_0 = {#"I0_7" #"I0_6" #"I0_5" #"I0_4" #"I0_3" #"I0_2" #"I0_1" #"I0_0"} @BUNDLE;
// %bundle_0 @PLACE(16, 0) => @ORIENT("R0");
// %bundle_0 @TEXT("I0<7:0>", key="name");
// #"I1" @PLACE(-8, 32) => @ORIENT("R0");
// #"I4" @PLACE(48, 32) => @ORIENT("R0");
// #"I2" @PLACE(-19, -23) => @ORIENT("R0");
// #"M24" @SET-SYMBOL %symbol_0;
// #"M24" @PLACE(-76, 8) => @ORIENT("MY");
// %port_0 = $IO_PORT @ATTACH &"VSS" => @PLACE(-7, 17) => @ORIENT("R90");
// %port_1 = $IO_PORT @ATTACH &"VSS" => @PLACE(19, -17) => @ORIENT("R90");
// %port_2 = $IO_PORT @ATTACH &"VDD" => @PLACE(-9, 17) => @ORIENT("R90");
// %port_3 = $IO_PORT @ATTACH &"VDD" => @PLACE(17, -17) => @ORIENT("R90");
// %input_port_symbol = @DEFINE-SYMBOL(box=[-2, -1, 0, 1]) {
// @LINE(fill="linecolor", linestyle="none") {(-2, -0.9) (-2, 0.9) (-0.9, 0.9) (0, 0) (-0.9, -0.9) (-2, -0.9)};
// (0, 0) @PIN(terminal=1, direction="right");
// ? @TEXT("${name}", key="name", halign="middle") => @PLACE(-1, 1.6)
// };
// %port_4 = $IO_PORT @ATTACH &"VINN" => @PLACE(-43, 2) => @ORIENT("R0");
// %port_4 @SET-SYMBOL %input_port_symbol;
// %port_4 @TEXT("VINN", key="name");
// %port_5 = $IO_PORT @ATTACH &"VINP" => @PLACE(-43, 4) => @ORIENT("R0");
// %port_5 @SET-SYMBOL %input_port_symbol;
// %port_5 @TEXT("VINP", key="name");
// %output_port_symbol = @DEFINE-SYMBOL(box=[0, -1, 2, 1]) {
// @LINE(fill="linecolor", linestyle="none") {(0, -0.9) (0, 0.9) (1.1, 0.9) (2, 0) (1.1, -0.9) (0, -0.9)};
// (0, 0) @PIN(terminal=1, direction="left");
// ? @TEXT("${name}", key="name", halign="middle") => @PLACE(1, 1.6)
// };
// %bus_port_type_6 = @DEFINE(roles=[["p", "net"], ["p1", "net"], ["p2", "net"], ["p3", "net"], ["p4", "net"], ["p5", "net"], ["p6", "net"], ["p7", "net"]]) {};
// %bus_port_type_6_symbol = @DEFINE-SYMBOL {(0, 0) @PIN(terminal=[1, 2, 3, 4, 5, 6, 7, 8])};
// {&"DN_7" &"DN_6" &"DN_5" &"DN_4" &"DN_3" &"DN_2" &"DN_1" &"DN_0"} @REMOVE-FROM $PORT_FILL_SET;
// %port_6 = %bus_port_type_6 @ATTACH &"DN_7" &"DN_6" &"DN_5" &"DN_4" &"DN_3" &"DN_2" &"DN_1" &"DN_0" => @PLACE(42, 0) => @ORIENT("R0");
// %port_6 @SET-SYMBOL %bus_port_type_6_symbol;
// %port_6_marker = $IO_PORT @ATTACH &"DN_7" => @PLACE(42, 0) => @ORIENT("R0");
// %port_6_marker @SET-SYMBOL %output_port_symbol;
// %port_6_marker @TEXT("DN<7:0>", key="name");
// %port_7 = $IO_PORT @ATTACH &"PHI2P" => @PLACE(22, 16) => @ORIENT("R270");
// %port_7 @SET-SYMBOL %input_port_symbol;
// %port_7 @TEXT("PHI2P", key="name");
// %bus_port_type_8 = @DEFINE(roles=[["p", "net"], ["p1", "net"], ["p2", "net"], ["p3", "net"], ["p4", "net"], ["p5", "net"], ["p6", "net"], ["p7", "net"]]) {};
// %bus_port_type_8_symbol = @DEFINE-SYMBOL {(0, 0) @PIN(terminal=[1, 2, 3, 4, 5, 6, 7, 8])};
// {&"DP_7" &"DP_6" &"DP_5" &"DP_4" &"DP_3" &"DP_2" &"DP_1" &"DP_0"} @REMOVE-FROM $PORT_FILL_SET;
// %port_8 = %bus_port_type_8 @ATTACH &"DP_7" &"DP_6" &"DP_5" &"DP_4" &"DP_3" &"DP_2" &"DP_1" &"DP_0" => @PLACE(42, 2) => @ORIENT("R0");
// %port_8 @SET-SYMBOL %bus_port_type_8_symbol;
// %port_8_marker = $IO_PORT @ATTACH &"DP_7" => @PLACE(42, 2) => @ORIENT("R0");
// %port_8_marker @SET-SYMBOL %output_port_symbol;
// %port_8_marker @TEXT("DP<7:0>", key="name");
// %port_9 = $IO_PORT @ATTACH &"VCM" => @PLACE(10, 17) => @ORIENT("R270");
// %port_10 = $IO_PORT @ATTACH &"PHI1N" => @PLACE(-8, 46) => @ORIENT("R270");
// %port_10 @SET-SYMBOL %input_port_symbol;
// %port_10 @TEXT("PHI1N", key="name");
// %bus_port_type_11 = @DEFINE(roles=[["p", "net"], ["p1", "net"], ["p2", "net"], ["p3", "net"], ["p4", "net"], ["p5", "net"], ["p6", "net"], ["p7", "net"]]) {};
// %bus_port_type_11_symbol = @DEFINE-SYMBOL {(0, 0) @PIN(terminal=[1, 2, 3, 4, 5, 6, 7, 8])};
// {&"D_7" &"D_6" &"D_5" &"D_4" &"D_3" &"D_2" &"D_1" &"D_0"} @REMOVE-FROM $PORT_FILL_SET;
// %port_11 = %bus_port_type_11 @ATTACH &"D_7" &"D_6" &"D_5" &"D_4" &"D_3" &"D_2" &"D_1" &"D_0" => @PLACE(42, -2) => @ORIENT("R0");
// %port_11 @SET-SYMBOL %bus_port_type_11_symbol;
// %port_11_marker = $IO_PORT @ATTACH &"D_7" => @PLACE(42, -2) => @ORIENT("R0");
// %port_11_marker @SET-SYMBOL %output_port_symbol;
// %port_11_marker @TEXT("D<7:0>", key="name");
// %port_12 = $IO_PORT @ATTACH &"VREFP" => @PLACE(-32, -22) => @ORIENT("R0");
// %port_13 = $IO_PORT @ATTACH &"VREFN" => @PLACE(-32, -24) => @ORIENT("R0");
// %port_14 = $IO_PORT @ATTACH &"IB" => @PLACE(-80, 49) => @ORIENT("R270");
// %port_15 = $IO_PORT @ATTACH &"PHI2N" => @PLACE(24, 16) => @ORIENT("R270");
// %port_15 @SET-SYMBOL %input_port_symbol;
// %port_15 @TEXT("PHI2N", key="name");
// %port_16 = $IO_PORT @ATTACH &"PHI1EN" => @PLACE(32, 32) => @ORIENT("R0");
// %port_16 @SET-SYMBOL %input_port_symbol;
// %port_16 @TEXT("PHI1EN", key="name");
// %bus_port_type_17 = @DEFINE(roles=[["p", "net"], ["p1", "net"], ["p2", "net"], ["p3", "net"], ["p4", "net"], ["p5", "net"], ["p6", "net"], ["p7", "net"], ["p8", "net"], ["p9", "net"], ["p10", "net"], ["p11", "net"], ["p12", "net"], ["p13", "net"], ["p14", "net"], ["p15", "net"], ["p16", "net"], ["p17", "net"], ["p18", "net"], ["p19", "net"], ["p20", "net"], ["p21", "net"], ["p22", "net"], ["p23", "net"], ["p24", "net"], ["p25", "net"], ["p26", "net"], ["p27", "net"], ["p28", "net"], ["p29", "net"], ["p30", "net"], ["p31", "net"], ["p32", "net"], ["p33", "net"], ["p34", "net"], ["p35", "net"], ["p36", "net"], ["p37", "net"], ["p38", "net"], ["p39", "net"], ["p40", "net"], ["p41", "net"], ["p42", "net"], ["p43", "net"], ["p44", "net"], ["p45", "net"], ["p46", "net"], ["p47", "net"], ["p48", "net"], ["p49", "net"], ["p50", "net"], ["p51", "net"], ["p52", "net"], ["p53", "net"], ["p54", "net"], ["p55", "net"]]) {};
// %bus_port_type_17_symbol = @DEFINE-SYMBOL {(0, 0) @PIN(terminal=[1, 2, 3, 4, 5, 6, 7, 8, 9, 10, 11, 12, 13, 14, 15, 16, 17, 18, 19, 20, 21, 22, 23, 24, 25, 26, 27, 28, 29, 30, 31, 32, 33, 34, 35, 36, 37, 38, 39, 40, 41, 42, 43, 44, 45, 46, 47, 48, 49, 50, 51, 52, 53, 54, 55, 56])};
// {&"SLCT_55" &"SLCT_54" &"SLCT_53" &"SLCT_52" &"SLCT_51" &"SLCT_50" &"SLCT_49" &"SLCT_48" &"SLCT_47" &"SLCT_46" &"SLCT_45" &"SLCT_44" &"SLCT_43" &"SLCT_42" &"SLCT_41" &"SLCT_40" &"SLCT_39" &"SLCT_38" &"SLCT_37" &"SLCT_36" &"SLCT_35" &"SLCT_34" &"SLCT_33" &"SLCT_32" &"SLCT_31" &"SLCT_30" &"SLCT_29" &"SLCT_28" &"SLCT_27" &"SLCT_26" &"SLCT_25" &"SLCT_24" &"SLCT_23" &"SLCT_22" &"SLCT_21" &"SLCT_20" &"SLCT_19" &"SLCT_18" &"SLCT_17" &"SLCT_16" &"SLCT_15" &"SLCT_14" &"SLCT_13" &"SLCT_12" &"SLCT_11" &"SLCT_10" &"SLCT_9" &"SLCT_8" &"SLCT_7" &"SLCT_6" &"SLCT_5" &"SLCT_4" &"SLCT_3" &"SLCT_2" &"SLCT_1" &"SLCT_0"} @REMOVE-FROM $PORT_FILL_SET;
// %port_17 = %bus_port_type_17 @ATTACH &"SLCT_55" &"SLCT_54" &"SLCT_53" &"SLCT_52" &"SLCT_51" &"SLCT_50" &"SLCT_49" &"SLCT_48" &"SLCT_47" &"SLCT_46" &"SLCT_45" &"SLCT_44" &"SLCT_43" &"SLCT_42" &"SLCT_41" &"SLCT_40" &"SLCT_39" &"SLCT_38" &"SLCT_37" &"SLCT_36" &"SLCT_35" &"SLCT_34" &"SLCT_33" &"SLCT_32" &"SLCT_31" &"SLCT_30" &"SLCT_29" &"SLCT_28" &"SLCT_27" &"SLCT_26" &"SLCT_25" &"SLCT_24" &"SLCT_23" &"SLCT_22" &"SLCT_21" &"SLCT_20" &"SLCT_19" &"SLCT_18" &"SLCT_17" &"SLCT_16" &"SLCT_15" &"SLCT_14" &"SLCT_13" &"SLCT_12" &"SLCT_11" &"SLCT_10" &"SLCT_9" &"SLCT_8" &"SLCT_7" &"SLCT_6" &"SLCT_5" &"SLCT_4" &"SLCT_3" &"SLCT_2" &"SLCT_1" &"SLCT_0" => @PLACE(-83, -31) => @ORIENT("R0");
// %port_17 @SET-SYMBOL %bus_port_type_17_symbol;
// %port_17_marker = $IO_PORT @ATTACH &"SLCT_55" => @PLACE(-83, -31) => @ORIENT("R0");
// %port_17_marker @SET-SYMBOL %input_port_symbol;
// %port_17_marker @TEXT("SLCT<55:0>", key="name");
// %p0 = (-84, -31);
// %wire_0 = {&"SLCT_55" &"SLCT_54" &"SLCT_53" &"SLCT_52" &"SLCT_51" &"SLCT_50" &"SLCT_49" &"SLCT_48" &"SLCT_47" &"SLCT_46" &"SLCT_45" &"SLCT_44" &"SLCT_43" &"SLCT_42" &"SLCT_41" &"SLCT_40" &"SLCT_39" &"SLCT_38" &"SLCT_37" &"SLCT_36" &"SLCT_35" &"SLCT_34" &"SLCT_33" &"SLCT_32" &"SLCT_31" &"SLCT_30" &"SLCT_29" &"SLCT_28" &"SLCT_27" &"SLCT_26" &"SLCT_25" &"SLCT_24" &"SLCT_23" &"SLCT_22" &"SLCT_21" &"SLCT_20" &"SLCT_19" &"SLCT_18" &"SLCT_17" &"SLCT_16" &"SLCT_15" &"SLCT_14" &"SLCT_13" &"SLCT_12" &"SLCT_11" &"SLCT_10" &"SLCT_9" &"SLCT_8" &"SLCT_7" &"SLCT_6" &"SLCT_5" &"SLCT_4" &"SLCT_3" &"SLCT_2" &"SLCT_1" &"SLCT_0"} @WIRE(mode="straight") {%p0 %port_17:1 #"I5":1};
// %wire_1 = &"net23" @WIRE(mode="straight") {#"M24":1 #"M0":3};
// %p1 = (-80, 32);
// %wire_2 = &"IB" @WIRE(mode="straight") {%p1 %port_14:p};
// %p2 = (-72, 8);
// %p3 = (-72, 16);
// %wire_3 = &"IB" @WIRE(mode="straight") {%p2 %p3};
// %wire_4 = &"IB" @WIRE(mode="straight") {#"M24":2 %p2};
// %p4 = (-72, 32);
// %wire_5 = &"IB" @WIRE(mode="straight") {%p1 %p4};
// %wire_6 = &"IB" @WIRE(mode="straight") {#"M0":1 %p1};
// %wire_7 = &"IB" @WIRE(mode="straight") {#"M1":2 %p2};
// %p5 = (-4, -4);
// %wire_8 = &"IB" @WIRE(mode="straight") {%p5 %bundle_0:11};
// %wire_9 = &"IB" @WIRE(mode="straight") {%p3 %p4};
// %p6 = (-64, 16);
// %wire_10 = &"IB" @WIRE(mode="straight") {#"C0":1 %p6};
// %wire_11 = &"IB" @WIRE(mode="straight") {%p3 %p6};
// %wire_8 @TEXT("IB", size=1, halign="middle", valign="baseline") => @PLACE(-2, -3.3);
// %p7 = (16, 17);
// %wire_12 = &"PHI1EPBUF" @WIRE(mode="straight") {%bundle_0:7 %p7};
// %p8 = (64, 34);
// %wire_13 = &"PHI1EPBUF" @WIRE(mode="straight") {#"I4":4 %p8};
// %wire_13 @TEXT("PHI1EPBUF", size=1, halign="middle", valign="baseline") => @PLACE(64, 34.7);
// %wire_12 @TEXT("PHI1EPBUF", size=1, halign="middle", valign="baseline", rotate=90) => @PLACE(15.3, 16);
// %wire_14 = &"PHI1EN" @WIRE(mode="straight") {%port_16:p #"I4":1};
// %p9 = (64, 32);
// %wire_15 = &"PHI1EPBST" @WIRE(mode="straight") {#"I4":3 %p9};
// %p10 = (18, 17);
// %wire_16 = &"PHI1EPBST" @WIRE(mode="straight") {%bundle_0:8 %p10};
// %wire_16 @TEXT("PHI1EPBST", size=1, halign="middle", valign="baseline", rotate=90) => @PLACE(17.3, 16);
// %wire_15 @TEXT("PHI1EPBST", size=1, halign="middle", valign="baseline") => @PLACE(64, 32.7);
// %p11 = (-41, -31);
// %wire_17 = {&"VOSP_7" &"VOSP_6" &"VOSP_5" &"VOSP_4" &"VOSP_3" &"VOSP_2" &"VOSP_1" &"VOSP_0"} @WIRE(mode="straight") {#"I5":73 %p11};
// %p12 = (-4, 0);
// %wire_18 = {&"VOSP_7" &"VOSP_6" &"VOSP_5" &"VOSP_4" &"VOSP_3" &"VOSP_2" &"VOSP_1" &"VOSP_0"} @WIRE(mode="straight") {%p12 %bundle_0:17};
// %wire_18 @TEXT("VOSP<7:0>", size=1, halign="middle", valign="baseline") => @PLACE(-4, 0.7);
// %wire_17 @TEXT("VOSP<7:0>", size=1, halign="middle", valign="baseline") => @PLACE(-41, -30.3);
// %p13 = (-41, -33);
// %wire_19 = {&"VOSN_7" &"VOSN_6" &"VOSN_5" &"VOSN_4" &"VOSN_3" &"VOSN_2" &"VOSN_1" &"VOSN_0"} @WIRE(mode="straight") {#"I5":65 %p13};
// %p14 = (-4, -2);
// %wire_20 = {&"VOSN_7" &"VOSN_6" &"VOSN_5" &"VOSN_4" &"VOSN_3" &"VOSN_2" &"VOSN_1" &"VOSN_0"} @WIRE(mode="straight") {%p14 %bundle_0:16};
// %wire_20 @TEXT("VOSN<7:0>", size=1, halign="middle", valign="baseline") => @PLACE(-4, -1.3);
// %wire_19 @TEXT("VOSN<7:0>", size=1, halign="middle", valign="baseline") => @PLACE(-41, -32.3);
// %p15 = (2, -27);
// %wire_21 = {&"VOSREF_2" &"VOSREF_1" &"VOSREF_0"} @WIRE(mode="straight") {#"I2":1 %p15};
// %wire_21 @TEXT("VOSREF<2:0>", size=1, halign="middle", valign="baseline") => @PLACE(2, -26.3);
// %p16 = (64, 30);
// %wire_22 = &"PHI1ENBUF" @WIRE(mode="straight") {#"I4":2 %p16};
// %p17 = (20, 16);
// %wire_23 = &"PHI1ENBUF" @WIRE(mode="straight") {%bundle_0:6 %p17};
// %wire_23 @TEXT("PHI1ENBUF", size=1, halign="middle", valign="baseline", rotate=90) => @PLACE(19.3, 16);
// %wire_22 @TEXT("PHI1ENBUF", size=1, halign="middle", valign="baseline") => @PLACE(64, 30.7);
// %wire_24 = &"VREFN" @WIRE(mode="straight") {%port_13:p #"I2":12};
// %wire_25 = &"VREFP" @WIRE(mode="straight") {%port_12:p #"I2":13};
// %p18 = (24, 17);
// %wire_26 = &"PHI2N" @WIRE(mode="straight") {%bundle_0:9 %port_15:p %p18};
// %p19 = (14, 31);
// %wire_27 = &"PHI1BSTN" @WIRE(mode="straight") {%bundle_0:4 %p19};
// %wire_28 = &"PHI1BSTN" @WIRE(mode="straight") {#"I1":2 %p19};
// %wire_27 @TEXT("PHI1BSTN", size=1, halign="middle", valign="baseline", rotate=90) => @PLACE(13.3, 15);
// %p20 = (2, -23);
// %wire_29 = {&"VREF_7" &"VREF_6" &"VREF_5" &"VREF_4" &"VREF_3" &"VREF_2" &"VREF_1" &"VREF_0"} @WIRE(mode="straight") {#"I2":4 %p20};
// %p21 = (13, -16);
// %wire_30 = {&"VREF_7" &"VREF_6" &"VREF_5" &"VREF_4" &"VREF_3" &"VREF_2" &"VREF_1" &"VREF_0"} @WIRE(mode="straight") {%p21 %bundle_0:19};
// %wire_30 @TEXT("VREF<7:0>", size=1, halign="middle", valign="baseline", rotate=90) => @PLACE(12.3, -16);
// %wire_29 @TEXT("VREF<7:0>", size=1, halign="middle", valign="baseline") => @PLACE(1, -22.3);
// %p22 = (15, -16);
// %wire_31 = {&"VREF_7" &"VREF_6" &"VREF_5" &"VREF_4" &"VREF_3" &"VREF_2" &"VREF_1" &"VREF_0"} @WIRE(mode="straight") {%p22 %bundle_0:18};
// %wire_31 @TEXT("VREF<0:7>", size=1, halign="middle", valign="baseline", rotate=90) => @PLACE(14.3, -16);
// %wire_32 = {&"D_7" &"D_6" &"D_5" &"D_4" &"D_3" &"D_2" &"D_1" &"D_0"} @WIRE(mode="straight") {%bundle_0:1 %port_11:1};
// %p23 = (12, 33);
// %wire_33 = &"PHI1BSTP" @WIRE(mode="straight") {#"I1":3 %p23};
// %wire_34 = &"PHI1BSTP" @WIRE(mode="straight") {%bundle_0:5 %p23};
// %wire_34 @TEXT("PHI1BSTP", size=1, halign="middle", valign="baseline", rotate=90) => @PLACE(11.3, 15);
// %wire_35 = &"PHI1N" @WIRE(mode="straight") {#"I1":1 %port_10:p};
// %p24 = (-88, 24);
// %wire_36 = &"VCM" @WIRE(mode="straight") {%p24 #"M0":2};
// %p25 = (10, 19);
// %wire_37 = &"VCM" @WIRE(mode="straight") {%bundle_0:12 %port_9:p %p25};
// %wire_36 @TEXT("VCM", size=1, halign="middle", valign="baseline") => @PLACE(-86, 24.7);
// %wire_38 = {&"DP_7" &"DP_6" &"DP_5" &"DP_4" &"DP_3" &"DP_2" &"DP_1" &"DP_0"} @WIRE(mode="straight") {%bundle_0:3 %port_8:1};
// %wire_39 = &"PHI2P" @WIRE(mode="straight") {%bundle_0:10 %port_7:p};
// %wire_40 = {&"DN_7" &"DN_6" &"DN_5" &"DN_4" &"DN_3" &"DN_2" &"DN_1" &"DN_0"} @WIRE(mode="straight") {%bundle_0:2 %port_6:1};
// %p26 = (-33, 4);
// %p27 = (-33, 33);
// %wire_41 = &"VINP" @WIRE(mode="straight") {%p26 %p27};
// %wire_42 = &"VINP" @WIRE(mode="straight") {%p27 #"I1":6};
// %wire_43 = &"VINP" @WIRE(mode="straight") {%p26 %bundle_0:15};
// %p28 = (-44, 4);
// %wire_44 = &"VINP" @WIRE(mode="straight") {%p28 %port_5:p %p26};
// %p29 = (-31, 31);
// %wire_45 = &"VINN" @WIRE(mode="straight") {%p29 #"I1":5};
// %p30 = (-44, 2);
// %p31 = (-31, 2);
// %wire_46 = &"VINN" @WIRE(mode="straight") {%p30 %port_4:p %p31};
// %wire_47 = &"VINN" @WIRE(mode="straight") {%p31 %bundle_0:14};
// %wire_48 = &"VINN" @WIRE(mode="straight") {%p31 %p29};
// %p32 = (-84, -33);
// %wire_49 = {&"VOSREF_2" &"VOSREF_1" &"VOSREF_0" &"VREF_5" &"VREF_4" &"VREF_3" &"VREF_2"} @WIRE(mode="straight") {%p32 #"I5":58};
// %wire_49 @TEXT("VREF<5>,VOSREF<2>,VREF<4>,VOSREF<1>,VREF<3>,VOSREF<0>,VREF<2>", size=1, halign="middle", valign="baseline") => @PLACE(-108, -32.3);
// %p33 = (-63, -45);
// %wire_50 = &"VDD" @WIRE(mode="straight") {%p33 #"I5":57};
// %p34 = (47, 18);
// %wire_51 = &"VDD" @WIRE(mode="straight") {%p34 #"I4":5};
// %p35 = (17, -19);
// %wire_52 = &"VDD" @WIRE(mode="straight") {%p35 %port_3:p %bundle_0:13};
// %p36 = (-9, 15);
// %wire_53 = &"VDD" @WIRE(mode="straight") {%p36 %port_2:p #"I1":4};
// %wire_51 @TEXT("VDD", size=1, halign="middle", valign="baseline", rotate=90) => @PLACE(46.3, 20);
// %wire_50 @TEXT("VDD", size=1, halign="middle", valign="baseline", rotate=90) => @PLACE(-63.7, -43);
// %p37 = (-71, -1);
// %wire_54 = &"VSS" @WIRE(mode="straight") {%p37 #"M1":4};
// %p38 = (-69, -1);
// %wire_55 = &"VSS" @WIRE(mode="straight") {%p37 %p38};
// %p39 = (-75, -1);
// %wire_56 = &"VSS" @WIRE(mode="straight") {%p39 %p37};
// %wire_57 = &"VSS" @WIRE(mode="straight") {%p38 #"M1":3};
// %p40 = (-61, -45);
// %wire_58 = &"VSS" @WIRE(mode="straight") {%p40 #"I5":81};
// %p41 = (-76, 23);
// %wire_59 = &"VSS" @WIRE(mode="straight") {#"M0":4 %p41};
// %p42 = (-80, 0);
// %wire_60 = &"VSS" @WIRE(mode="straight") {%p42 #"M24":3};
// %p43 = (-81, 5);
// %wire_61 = &"VSS" @WIRE(mode="straight") {%p43 #"M24":3};
// %p44 = (-81, 7);
// %wire_62 = &"VSS" @WIRE(mode="straight") {%p44 #"M24":4};
// %wire_63 = &"VSS" @WIRE(mode="straight") {%p43 %p44};
// %wire_64 = &"VSS" @WIRE(mode="straight") {%p39 #"M1":1};
// %p45 = (49, 18);
// %wire_65 = &"VSS" @WIRE(mode="straight") {%p45 #"I4":6};
// %p46 = (-64, 0);
// %wire_66 = &"VSS" @WIRE(mode="straight") {%p46 #"C0":2};
// %p47 = (19, -19);
// %wire_67 = &"VSS" @WIRE(mode="straight") {%p47 %port_1:p %bundle_0:20};
// %p48 = (-7, 15);
// %wire_68 = &"VSS" @WIRE(mode="straight") {%p48 %port_0:p #"I1":7};
// %wire_66 @TEXT("VSS", size=1, halign="middle", valign="baseline", rotate=90) => @PLACE(-64.7, 3);
// %wire_65 @TEXT("VSS", size=1, halign="middle", valign="baseline", rotate=90) => @PLACE(48.3, 20);
// %wire_56 @TEXT("VSS", size=1, halign="middle", valign="baseline") => @PLACE(-73, -0.3);
// %wire_60 @TEXT("VSS", size=1, halign="middle", valign="baseline", rotate=90) => @PLACE(-80.7, 2);
// %wire_59 @TEXT("VSS", size=1, halign="middle", valign="baseline") => @PLACE(-77, 23.7);
// %wire_58 @TEXT("VSS", size=1, halign="middle", valign="baseline", rotate=90) => @PLACE(-61.7, -43);
// $JUNCTION @ATTACH %p1;
// $JUNCTION @ATTACH %p2;
// $JUNCTION @ATTACH %p3;
// $JUNCTION @ATTACH %p26;
// $JUNCTION @ATTACH %p31;
// $JUNCTION @ATTACH %p37
// }
ends L3_stage1_flash
