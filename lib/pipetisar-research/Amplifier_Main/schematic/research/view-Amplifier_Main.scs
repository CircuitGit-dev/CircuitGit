// Explicit saved-library assembly.
simulator lang=spectre
include "Amplifier_Main.scs"
