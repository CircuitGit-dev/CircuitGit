// @RNL(type="header") {
// @VERSION("0.3");
// @USE-PACKAGE(name="rnl-std-spectre", version="0.3", path="rnl-std-spectre.rnl");
// @USE-PACKAGE(name="eda-symbol", version="0.1", path="eda-symbol.rnl");
// @USE-PACKAGE(name="eda-style", version="0.1", path="eda-style.rnl")
// }
// Design: 2026_PIPESAR/L3_9bit_SAR_2
simulator lang=spectre
global 0

// 2026_PIPESAR/L5_9bit_Bootstrap/schematic

// 2026_PIPESAR/L6_9bit_RSW/schematic

// 2026_PIPESAR/L5_9bit_RSW_CDAC/schematic

// 2026_PIPESAR/L5_9bit_Comparator_LN/schematic

// 2026_PIPESAR/L6_SR_latch_1/schematic

// 2026_PIPESAR/L6_9bit_REF_Logic/schematic

// 2026_PIPESAR/L5_9bit_SAR_Logic_1/schematic

// 2026_PIPESAR/L3_9bit_SAR_2/schematic
subckt L3_9bit_SAR_2 CLKD TOPPB TOPNB VBSTN VCALB D_9 D_8 D_7 D_6 D_5 D_4 D_3 D_2 D_1 D_0 VINP VINN VREFN VREFP VBSTP CLKB CLKAE CLKA VCM DVSS DVDD AVSS AVDD
M1 (TOPNB CLKAEB VCM AVDD) pch_lvt_mac l=30n w=4u multi=3 nf=8
M0 (TOPPB CLKAEB VCM AVDD) pch_lvt_mac l=30n w=4u multi=3 nf=8
I16 (CLKA VBSTP AVDD VINP AVSS) L5_9bit_Bootstrap
I15 (CLKA VBSTN AVDD VINN AVSS) L5_9bit_Bootstrap
I17 (BOTN_9 BOTN_8 BOTN_7 BOTN_6 BOTN_5 BOTN_4 BOTN_3 BOTN_2 BOTN_1 BOTN_0 CLKB_B DVDD DVSS RNN_9 RNN_8 RNN_7 RNN_6 RNN_5 RNN_4 RNN_3 RNN_2 RNN_1 RPN_9 RPN_8 RPN_7 RPN_6 RPN_5 RPN_4 RPN_3 RPN_2 RPN_1 TOPNB VBSTN VINN VREFN VREFP) L5_9bit_RSW_CDAC
I18 (BOTP_9 BOTP_8 BOTP_7 BOTP_6 BOTP_5 BOTP_4 BOTP_3 BOTP_2 BOTP_1 BOTP_0 CLKB_B DVDD DVSS RNP_9 RNP_8 RNP_7 RNP_6 RNP_5 RNP_4 RNP_3 RNP_2 RNP_1 RPP_9 RPP_8 RPP_7 RPP_6 RPP_5 RPP_4 RPP_3 RPP_2 RPP_1 TOPPB VBSTP VINP VREFN VREFP) L5_9bit_RSW_CDAC
I0 (CLKC COMPN COMPP VCALB VCM AVDD TOPNB TOPPB AVSS) L5_9bit_Comparator_LN
I1 (CLKAE CLKAEB CLKB CLKB_B CLKC CLKD COMPN COMPP D_9 D_8 D_7 D_6 D_5 D_4 D_3 D_2 D_1 D_0 DN_9 DN_8 DN_7 DN_6 DN_5 DN_4 DN_3 DN_2 DN_1 DN_0 DP_9 DP_8 DP_7 DP_6 DP_5 DP_4 DP_3 DP_2 DP_1 DP_0 RNN_9 RNN_8 RNN_7 RNN_6 RNN_5 RNN_4 RNN_3 RNN_2 RNN_1 RNP_9 RNP_8 RNP_7 RNP_6 RNP_5 RNP_4 RNP_3 RNP_2 RNP_1 RPN_9 RPN_8 RPN_7 RPN_6 RPN_5 RPN_4 RPN_3 RPN_2 RPN_1 RPP_9 RPP_8 RPP_7 RPP_6 RPP_5 RPP_4 RPP_3 RPP_2 RPP_1 DVDD DVSS) L5_9bit_SAR_Logic_1
// @RNL(author="rnl-virtuoso") {
// %block_symbol = @DEFINE-SYMBOL(box=[0, -18, 34, 11]) {
// @LINE {(0, -6) (4, -6)};
// @LINE {(0, -4) (4, -4)};
// @LINE {(0, -2) (4, -2)};
// @LINE {(0, 0) (4, 0)};
// @LINE {(34, 0) (30, 0)};
// @LINE {(12, 11) (12, 7)};
// @LINE {(14, 11) (14, 7)};
// @LINE {(16, 11) (16, 7)};
// @LINE {(18, 11) (18, 7)};
// @LINE {(20, 11) (20, 7)};
// @LINE {(22, 11) (22, 7)};
// @LINE {(12, -18) (12, -14)};
// @LINE {(14, -18) (14, -14)};
// @LINE {(16, -18) (16, -14)};
// @RECTANGLE {(4, -14) (30, 7)};
// @LINE {(34, -2) (30, -2)};
// @LINE {(34, -4) (30, -4)};
// @LINE {(34, -6) (30, -6)};
// @LINE {(34, -8) (30, -8)};
// @LINE {(24, 11) (24, 7)};
// ? @TEXT("${name}", size=1, halign="start", valign="middle", key="name") => @PLACE(30, 7);
// ? @TEXT("${model}", size=1, halign="middle", valign="middle", key="model") => @PLACE(17, -3.5);
// (22, 11) @PIN(terminal="CLKB");
// (22, 6.4) @TEXT("CLKB", size=1, halign="end", valign="middle", rotate=90);
// (0, -4) @PIN(terminal="VCM");
// (4.6, -4) @TEXT("VCM", size=1, halign="start", valign="middle");
// (0, 0) @PIN(terminal="VINP");
// (4.6, 0) @TEXT("VINP", size=1, halign="start", valign="middle");
// (0, -2) @PIN(terminal="VINN");
// (4.6, -2) @TEXT("VINN", size=1, halign="start", valign="middle");
// (34, 0) @PIN(terminal=["D_9", "D_8", "D_7", "D_6", "D_5", "D_4", "D_3", "D_2", "D_1", "D_0"]);
// (29.4, 0) @TEXT("D<9:0>", size=1, halign="end", valign="middle");
// (12, 11) @PIN(terminal="DVDD");
// (12, 6.4) @TEXT("DVDD", size=1, halign="end", valign="middle", rotate=90);
// (14, 11) @PIN(terminal="AVDD");
// (14, 6.4) @TEXT("AVDD", size=1, halign="end", valign="middle", rotate=90);
// (16, 11) @PIN(terminal="VREFP");
// (16, 6.4) @TEXT("VREFP", size=1, halign="end", valign="middle", rotate=90);
// (34, -2) @PIN(terminal="VBSTP");
// (29.4, -2) @TEXT("VBSTP", size=1, halign="end", valign="middle");
// (18, 11) @PIN(terminal="CLKA");
// (18, 6.4) @TEXT("CLKA", size=1, halign="end", valign="middle", rotate=90);
// (20, 11) @PIN(terminal="CLKAE");
// (20, 6.4) @TEXT("CLKAE", size=1, halign="end", valign="middle", rotate=90);
// (12, -18) @PIN(terminal="DVSS");
// (12, -13.4) @TEXT("DVSS", size=1, halign="start", valign="middle", rotate=90);
// (14, -18) @PIN(terminal="AVSS");
// (14, -13.4) @TEXT("AVSS", size=1, halign="start", valign="middle", rotate=90);
// (16, -18) @PIN(terminal="VREFN");
// (16, -13.4) @TEXT("VREFN", size=1, halign="start", valign="middle", rotate=90);
// (0, -6) @PIN(terminal="VCALB");
// (4.6, -6) @TEXT("VCALB", size=1, halign="start", valign="middle");
// (34, -4) @PIN(terminal="VBSTN");
// (29.4, -4) @TEXT("VBSTN", size=1, halign="end", valign="middle");
// (34, -8) @PIN(terminal="TOPNB");
// (29.4, -8) @TEXT("TOPNB", size=1, halign="end", valign="middle");
// (34, -6) @PIN(terminal="TOPPB");
// (29.4, -6) @TEXT("TOPPB", size=1, halign="end", valign="middle");
// (24, 11) @PIN(terminal="CLKD");
// (24, 6.4) @TEXT("CLKD", size=1, halign="end", valign="middle", rotate=90)
// };
// # @SET-SYMBOL %block_symbol;
// %symbol_0 = @DEFINE-SYMBOL(box=[-0.1, -2.8, 3.8, 2.8]) {
// @LINE {(0, 0) (0.7, 0)};
// @LINE {(1.5, 1.5) (1.5, -1.5)};
// @LINE {(2, -1.5) (4, -1.5) (4, -3)};
// @LINE {(2, 1.5) (4, 1.5) (4, 3)};
// (1.1, 0) @CIRCLE(radius=0.4);
// @LINE {(3.7, 2) (2.7, 1.5) (3.7, 1)};
// @LINE {(2, -1.5) (2, 1.5)};
// ? @TEXT("${name}", size=0.8, halign="start", valign="baseline", key="name") => @PLACE(4.9, 3.4);
// ? @TEXT("${model}", size=0.8, halign="end", valign="baseline", key="model") => @PLACE(3.3, 3.2);
// (4, 3) @PIN(terminal=3);
// (4, 1) @PIN(terminal=4);
// (0, 0) @PIN(terminal=2);
// (4, -3) @PIN(terminal=1)
// };
// #"M1" @SET-SYMBOL %symbol_0;
// #"M1" @PLACE(-2, 24) => @ORIENT("MY");
// #"M0" @SET-SYMBOL %symbol_0;
// #"M0" @PLACE(-2, -26) => @ORIENT("R180");
// #"I0" @PLACE(6, 0) => @ORIENT("R0");
// #"I16" @PLACE(-99, -17) => @ORIENT("MX");
// #"I1" @PLACE(29, 2) => @ORIENT("R0");
// #"I18" @PLACE(-55, -17) => @ORIENT("R0");
// #"I15" @PLACE(-99, 15) => @ORIENT("R0");
// #"I17" @PLACE(-55, 15) => @ORIENT("MX");
// %marker_1 = (-15, 17);
// $FIGURE @ATTACH %marker_1 => @SET-SYMBOL $NO_CONNECT_SYMBOL => @ORIENT("R90");
// %marker_12 = (67, 1);
// $FIGURE @ATTACH %marker_12 => @SET-SYMBOL $NO_CONNECT_SYMBOL => @ORIENT("R90");
// %marker_28 = (67, -1);
// $FIGURE @ATTACH %marker_28 => @SET-SYMBOL $NO_CONNECT_SYMBOL => @ORIENT("R90");
// %marker_38 = (-15, -19);
// $FIGURE @ATTACH %marker_38 => @SET-SYMBOL $NO_CONNECT_SYMBOL => @ORIENT("R90");
// %port_0 = $IO_PORT @ATTACH &"AVDD" => @PLACE(-116, 32) => @ORIENT("R0");
// %port_1 = $IO_PORT @ATTACH &"AVSS" => @PLACE(-116, 29) => @ORIENT("R0");
// %port_2 = $IO_PORT @ATTACH &"DVDD" => @PLACE(-116, 26) => @ORIENT("R0");
// %port_3 = $IO_PORT @ATTACH &"DVSS" => @PLACE(-116, 23) => @ORIENT("R0");
// %port_4 = $IO_PORT @ATTACH &"VCM" => @PLACE(-116, 20) => @ORIENT("R0");
// %input_port_symbol = @DEFINE-SYMBOL(box=[-2, -1, 0, 1]) {
// @LINE(fill="linecolor", linestyle="none") {(-2, -0.9) (-2, 0.9) (-0.9, 0.9) (0, 0) (-0.9, -0.9) (-2, -0.9)};
// (0, 0) @PIN(terminal=1, direction="right");
// ? @TEXT("${name}", key="name", halign="middle") => @PLACE(-1, 1.6)
// };
// %port_5 = $IO_PORT @ATTACH &"CLKA" => @PLACE(-115, 14) => @ORIENT("R0");
// %port_5 @SET-SYMBOL %input_port_symbol;
// %port_5 @TEXT("CLKA", key="name");
// %port_6 = $IO_PORT @ATTACH &"CLKAE" => @PLACE(-115, 11) => @ORIENT("R0");
// %port_6 @SET-SYMBOL %input_port_symbol;
// %port_6 @TEXT("CLKAE", key="name");
// %port_7 = $IO_PORT @ATTACH &"CLKB" => @PLACE(-115, 8) => @ORIENT("R0");
// %port_7 @SET-SYMBOL %input_port_symbol;
// %port_7 @TEXT("CLKB", key="name");
// %output_port_symbol = @DEFINE-SYMBOL(box=[0, -1, 2, 1]) {
// @LINE(fill="linecolor", linestyle="none") {(0, -0.9) (0, 0.9) (1.1, 0.9) (2, 0) (1.1, -0.9) (0, -0.9)};
// (0, 0) @PIN(terminal=1, direction="left");
// ? @TEXT("${name}", key="name", halign="middle") => @PLACE(1, 1.6)
// };
// %port_8 = $IO_PORT @ATTACH &"VBSTP" => @PLACE(-117, -10) => @ORIENT("R0");
// %port_8 @SET-SYMBOL %output_port_symbol;
// %port_8 @TEXT("VBSTP", key="name");
// %port_9 = $IO_PORT @ATTACH &"VREFP" => @PLACE(-116, 5) => @ORIENT("R0");
// %port_10 = $IO_PORT @ATTACH &"VREFN" => @PLACE(-116, 2) => @ORIENT("R0");
// %port_11 = $IO_PORT @ATTACH &"VINN" => @PLACE(-115, -1) => @ORIENT("R0");
// %port_11 @SET-SYMBOL %input_port_symbol;
// %port_11 @TEXT("VINN", key="name");
// %port_12 = $IO_PORT @ATTACH &"VINP" => @PLACE(-115, -4) => @ORIENT("R0");
// %port_12 @SET-SYMBOL %input_port_symbol;
// %port_12 @TEXT("VINP", key="name");
// %bus_port_type_13 = @DEFINE(roles=[["p", "net"], ["p1", "net"], ["p2", "net"], ["p3", "net"], ["p4", "net"], ["p5", "net"], ["p6", "net"], ["p7", "net"], ["p8", "net"], ["p9", "net"]]) {};
// %bus_port_type_13_symbol = @DEFINE-SYMBOL {(0, 0) @PIN(terminal=[1, 2, 3, 4, 5, 6, 7, 8, 9, 10])};
// {&"D_9" &"D_8" &"D_7" &"D_6" &"D_5" &"D_4" &"D_3" &"D_2" &"D_1" &"D_0"} @REMOVE-FROM $PORT_FILL_SET;
// %port_13 = %bus_port_type_13 @ATTACH &"D_9" &"D_8" &"D_7" &"D_6" &"D_5" &"D_4" &"D_3" &"D_2" &"D_1" &"D_0" => @PLACE(-116, -7) => @ORIENT("R0");
// %port_13 @SET-SYMBOL %bus_port_type_13_symbol;
// %port_13_marker = $IO_PORT @ATTACH &"D_9" => @PLACE(-116, -7) => @ORIENT("R0");
// %port_13_marker @TEXT("D<9:0>", key="name");
// %port_14 = $IO_PORT @ATTACH &"VCALB" => @PLACE(-116, 17) => @ORIENT("R0");
// %port_15 = $IO_PORT @ATTACH &"VBSTN" => @PLACE(-117, -13) => @ORIENT("R0");
// %port_15 @SET-SYMBOL %output_port_symbol;
// %port_15 @TEXT("VBSTN", key="name");
// %port_16 = $IO_PORT @ATTACH &"TOPNB" => @PLACE(-116, -19) => @ORIENT("R0");
// %port_17 = $IO_PORT @ATTACH &"TOPPB" => @PLACE(-116, -16) => @ORIENT("R0");
// %port_18 = $IO_PORT @ATTACH &"CLKD" => @PLACE(-115, -22) => @ORIENT("R0");
// %port_18 @SET-SYMBOL %input_port_symbol;
// %port_18 @TEXT("CLKD", key="name");
// %p0 = (67, -13);
// %wire_0 = &"CLKAEB" @WIRE(mode="straight") {#"I1":2 %p0};
// %p1 = (3, -26);
// %wire_1 = &"CLKAEB" @WIRE(mode="straight") {#"M0":2 %p1};
// %p2 = (3, 24);
// %wire_2 = &"CLKAEB" @WIRE(mode="straight") {#"M1":2 %p2};
// %wire_2 @TEXT("CLKAEB", size=1, halign="middle", valign="baseline") => @PLACE(1, 24.7);
// %wire_1 @TEXT("CLKAEB", size=1, halign="middle", valign="top") => @PLACE(1, -26.7);
// %wire_0 @TEXT("CLKAEB", size=1, halign="start", valign="baseline") => @PLACE(63.4, -12.3);
// %p3 = (-6, 15);
// %wire_3 = &"TOPNB" @WIRE(mode="straight") {%p3 #"M1":1};
// %p4 = (-6, 0);
// %wire_4 = &"TOPNB" @WIRE(mode="straight") {%p4 #"I0":7};
// %wire_5 = &"TOPNB" @WIRE(mode="straight") {#"I17":32 %p3};
// %wire_6 = &"TOPNB" @WIRE(mode="straight") {%p4 %p3};
// %wire_5 @TEXT("TOPNB", size=1, halign="start", valign="top") => @PLACE(-14.6, 14.3);
// %p5 = (-35, -37);
// %wire_7 = &"CLKB_B" @WIRE(mode="straight") {%p5 #"I18":11};
// %p6 = (-35, 35);
// %wire_8 = &"CLKB_B" @WIRE(mode="straight") {#"I17":11 %p6};
// %p7 = (67, 5);
// %wire_9 = &"CLKB_B" @WIRE(mode="straight") {#"I1":4 %p7};
// %wire_9 @TEXT("CLKB\_B", size=1, halign="start", valign="baseline") => @PLACE(63.4, 5.7);
// %wire_8 @TEXT("CLKB\_B", size=1, halign="start", valign="baseline", rotate=90) => @PLACE(-35.7, 31.4);
// %wire_7 @TEXT("CLKB\_B", size=1, halign="end", valign="baseline", rotate=90) => @PLACE(-35.7, -33.4);
// %p8 = (47, -23);
// %wire_10 = &"CLKD" @WIRE(mode="straight") {%p8 #"I1":6};
// %wire_10 @TEXT("CLKD", size=1, halign="end", valign="baseline", rotate=90) => @PLACE(46.3, -19.4);
// %wire_11 = {&"DN_9" &"DN_8" &"DN_7" &"DN_6" &"DN_5" &"DN_4" &"DN_3" &"DN_2" &"DN_1" &"DN_0"} @WIRE(mode="straight") {#"I1":19 %marker_12};
// %wire_11 @TEXT("DN<9:0>", size=1, halign="start", valign="baseline") => @PLACE(63.4, 2.2);
// %wire_12 = {&"DP_9" &"DP_8" &"DP_7" &"DP_6" &"DP_5" &"DP_4" &"DP_3" &"DP_2" &"DP_1" &"DP_0"} @WIRE(mode="straight") {#"I1":29 %marker_28};
// %wire_12 @TEXT("DP<9:0>", size=1, halign="start", valign="baseline") => @PLACE(63.4, 0.2);
// %p9 = (67, -9);
// %wire_13 = {&"RPP_9" &"RPP_8" &"RPP_7" &"RPP_6" &"RPP_5" &"RPP_4" &"RPP_3" &"RPP_2" &"RPP_1"} @WIRE(mode="straight") {#"I1":66 %p9};
// %p10 = (-59, -19);
// %wire_14 = {&"RPP_9" &"RPP_8" &"RPP_7" &"RPP_6" &"RPP_5" &"RPP_4" &"RPP_3" &"RPP_2" &"RPP_1"} @WIRE(mode="straight") {%p10 #"I18":23};
// %wire_14 @TEXT("RPP<9:1>", size=1, halign="end", valign="baseline") => @PLACE(-55.4, -17.8);
// %wire_13 @TEXT("RPP<9:1>", size=1, halign="start", valign="baseline") => @PLACE(63.4, -7.8);
// %p11 = (-59, 17);
// %wire_15 = {&"RPN_9" &"RPN_8" &"RPN_7" &"RPN_6" &"RPN_5" &"RPN_4" &"RPN_3" &"RPN_2" &"RPN_1"} @WIRE(mode="straight") {%p11 #"I17":23};
// %p12 = (67, -5);
// %wire_16 = {&"RPN_9" &"RPN_8" &"RPN_7" &"RPN_6" &"RPN_5" &"RPN_4" &"RPN_3" &"RPN_2" &"RPN_1"} @WIRE(mode="straight") {#"I1":57 %p12};
// %wire_16 @TEXT("RPN<9:1>", size=1, halign="start", valign="baseline") => @PLACE(63.4, -3.8);
// %wire_15 @TEXT("RPN<9:1>", size=1, halign="end", valign="baseline") => @PLACE(-55.4, 18.2);
// %p13 = (67, -11);
// %wire_17 = {&"RNP_9" &"RNP_8" &"RNP_7" &"RNP_6" &"RNP_5" &"RNP_4" &"RNP_3" &"RNP_2" &"RNP_1"} @WIRE(mode="straight") {#"I1":48 %p13};
// %p14 = (-59, -17);
// %wire_18 = {&"RNP_9" &"RNP_8" &"RNP_7" &"RNP_6" &"RNP_5" &"RNP_4" &"RNP_3" &"RNP_2" &"RNP_1"} @WIRE(mode="straight") {%p14 #"I18":14};
// %wire_18 @TEXT("RNP<9:1>", size=1, halign="end", valign="baseline") => @PLACE(-55.4, -15.8);
// %wire_17 @TEXT("RNP<9:1>", size=1, halign="start", valign="baseline") => @PLACE(63.4, -9.8);
// %p15 = (-59, 15);
// %wire_19 = {&"RNN_9" &"RNN_8" &"RNN_7" &"RNN_6" &"RNN_5" &"RNN_4" &"RNN_3" &"RNN_2" &"RNN_1"} @WIRE(mode="straight") {%p15 #"I17":14};
// %p16 = (67, -7);
// %wire_20 = {&"RNN_9" &"RNN_8" &"RNN_7" &"RNN_6" &"RNN_5" &"RNN_4" &"RNN_3" &"RNN_2" &"RNN_1"} @WIRE(mode="straight") {#"I1":39 %p16};
// %wire_20 @TEXT("RNN<9:1>", size=1, halign="start", valign="baseline") => @PLACE(63.4, -5.8);
// %wire_19 @TEXT("RNN<9:1>", size=1, halign="end", valign="baseline") => @PLACE(-55.4, 16.2);
// %wire_21 = {&"BOTN_9" &"BOTN_8" &"BOTN_7" &"BOTN_6" &"BOTN_5" &"BOTN_4" &"BOTN_3" &"BOTN_2" &"BOTN_1" &"BOTN_0"} @WIRE(mode="straight") {#"I17":1 %marker_1};
// %wire_21 @TEXT("BOTN<9:0>", size=1, halign="start", valign="baseline") => @PLACE(-18.6, 18.2);
// %wire_22 = {&"BOTP_9" &"BOTP_8" &"BOTP_7" &"BOTP_6" &"BOTP_5" &"BOTP_4" &"BOTP_3" &"BOTP_2" &"BOTP_1" &"BOTP_0"} @WIRE(mode="straight") {#"I18":1 %marker_38};
// %wire_22 @TEXT("BOTP<9:0>", size=1, halign="start", valign="baseline") => @PLACE(-18.6, -20.8);
// %p17 = (2, 3);
// %wire_23 = &"VCALB" @WIRE(mode="straight") {%p17 #"I0":4};
// %wire_23 @TEXT("VCALB", size=1, halign="end", valign="baseline") => @PLACE(5.6, 3.7);
// %p18 = (67, -3);
// %wire_24 = {&"D_9" &"D_8" &"D_7" &"D_6" &"D_5" &"D_4" &"D_3" &"D_2" &"D_1" &"D_0"} @WIRE(mode="straight") {#"I1":9 %p18};
// %wire_24 @TEXT("D<9:0>", size=1, halign="start", valign="baseline") => @PLACE(63.4, -1.8);
// %p19 = (-37, 0);
// %wire_25 = &"VREFP" @WIRE(mode="straight") {%p19 #"I17":36};
// %p20 = (-37, -2);
// %wire_26 = &"VREFP" @WIRE(mode="straight") {#"I18":36 %p20};
// %wire_26 @TEXT("VREFP", size=1, halign="start", valign="baseline", rotate=90) => @PLACE(-37.7, -5.6);
// %wire_25 @TEXT("VREFP", size=1, halign="end", valign="baseline", rotate=90) => @PLACE(-37.7, 3.6);
// %p21 = (-37, 35);
// %wire_27 = &"VREFN" @WIRE(mode="straight") {#"I17":35 %p21};
// %p22 = (-37, -37);
// %wire_28 = &"VREFN" @WIRE(mode="straight") {%p22 #"I18":35};
// %wire_28 @TEXT("VREFN", size=1, halign="end", valign="baseline", rotate=90) => @PLACE(-37.7, -33.4);
// %wire_27 @TEXT("VREFN", size=1, halign="start", valign="baseline", rotate=90) => @PLACE(-37.7, 31.4);
// %p23 = (-103, -17);
// %wire_29 = &"VINP" @WIRE(mode="straight") {%p23 #"I16":4};
// %p24 = (-59, -21);
// %wire_30 = &"VINP" @WIRE(mode="straight") {%p24 #"I18":34};
// %wire_30 @TEXT("VINP", size=1, halign="end", valign="baseline") => @PLACE(-55.4, -20.3);
// %wire_29 @TEXT("VINP", size=1, halign="end", valign="top") => @PLACE(-99.4, -17.7);
// %p25 = (-59, 19);
// %wire_31 = &"VINN" @WIRE(mode="straight") {%p25 #"I17":34};
// %p26 = (-103, 15);
// %wire_32 = &"VINN" @WIRE(mode="straight") {%p26 #"I15":4};
// %wire_32 @TEXT("VINN", size=1, halign="end", valign="baseline") => @PLACE(-99.4, 15.7);
// %wire_31 @TEXT("VINN", size=1, halign="end", valign="baseline") => @PLACE(-55.4, 19.7);
// %p27 = (-6, -33);
// %wire_33 = &"VCM" @WIRE(mode="straight") {#"M0":3 %p27};
// %p28 = (-6, 31);
// %wire_34 = &"VCM" @WIRE(mode="straight") {#"M1":3 %p28};
// %p29 = (2, -5);
// %wire_35 = &"VCM" @WIRE(mode="straight") {%p29 #"I0":5};
// %wire_35 @TEXT("VCM", size=1, halign="end", valign="baseline") => @PLACE(5.6, -4.3);
// %wire_34 @TEXT("VCM", size=1, halign="middle", valign="baseline", rotate=90) => @PLACE(-6.7, 29);
// %wire_33 @TEXT("VCM", size=1, halign="middle", valign="baseline", rotate=90) => @PLACE(-6.7, -31);
// %p30 = (-84, -30);
// %wire_36 = &"CLKA" @WIRE(mode="straight") {#"I16":1 %p30};
// %p31 = (-84, 28);
// %wire_37 = &"CLKA" @WIRE(mode="straight") {#"I15":1 %p31};
// %wire_37 @TEXT("CLKA", size=1, halign="start", valign="baseline", rotate=90) => @PLACE(-84.7, 24.4);
// %wire_36 @TEXT("CLKA", size=1, halign="end", valign="baseline", rotate=90) => @PLACE(-84.7, -26.4);
// %p32 = (-67, -17);
// %wire_38 = &"VBSTP" @WIRE(mode="straight") {#"I16":2 %p32};
// %p33 = (-35, -2);
// %wire_39 = &"VBSTP" @WIRE(mode="straight") {#"I18":33 %p33};
// %wire_39 @TEXT("VBSTP", size=1, halign="start", valign="baseline", rotate=90) => @PLACE(-35.7, -5.6);
// %wire_38 @TEXT("VBSTP", size=1, halign="start", valign="top") => @PLACE(-70.6, -17.7);
// %p34 = (-67, 15);
// %wire_40 = &"VBSTN" @WIRE(mode="straight") {#"I15":2 %p34};
// %p35 = (-35, 0);
// %wire_41 = &"VBSTN" @WIRE(mode="straight") {%p35 #"I17":33};
// %wire_41 @TEXT("VBSTN", size=1, halign="end", valign="baseline", rotate=90) => @PLACE(-35.7, 3.6);
// %wire_40 @TEXT("VBSTN", size=1, halign="start", valign="baseline") => @PLACE(-70.6, 15.7);
// %p36 = (-39, 35);
// %wire_42 = &"DVSS" @WIRE(mode="straight") {#"I17":13 %p36};
// %p37 = (45, -23);
// %wire_43 = &"DVSS" @WIRE(mode="straight") {%p37 #"I1":76};
// %p38 = (-39, -37);
// %wire_44 = &"DVSS" @WIRE(mode="straight") {%p38 #"I18":13};
// %wire_44 @TEXT("DVSS", size=1, halign="end", valign="baseline", rotate=90) => @PLACE(-39.7, -33.4);
// %wire_43 @TEXT("DVSS", size=1, halign="end", valign="baseline", rotate=90) => @PLACE(44.3, -19.4);
// %wire_42 @TEXT("DVSS", size=1, halign="start", valign="baseline", rotate=90) => @PLACE(-39.7, 31.4);
// %p39 = (-39, 0);
// %wire_45 = &"DVDD" @WIRE(mode="straight") {%p39 #"I17":12};
// %p40 = (45, 15);
// %wire_46 = &"DVDD" @WIRE(mode="straight") {#"I1":75 %p40};
// %p41 = (-39, -2);
// %wire_47 = &"DVDD" @WIRE(mode="straight") {#"I18":12 %p41};
// %wire_47 @TEXT("DVDD", size=1, halign="start", valign="baseline", rotate=90) => @PLACE(-39.7, -5.6);
// %wire_46 @TEXT("DVDD", size=1, halign="start", valign="baseline", rotate=90) => @PLACE(44.3, 11.4);
// %wire_45 @TEXT("DVDD", size=1, halign="end", valign="baseline", rotate=90) => @PLACE(-39.7, 3.6);
// %wire_48 = &"COMPP" @WIRE(mode="straight") {#"I0":3 #"I1":8};
// %wire_48 @TEXT("COMPP", size=1, halign="start", valign="baseline") => @PLACE(22.4, 0.7);
// %wire_49 = &"COMPN" @WIRE(mode="straight") {#"I0":2 #"I1":7};
// %wire_49 @TEXT("COMPN", size=1, halign="start", valign="baseline") => @PLACE(22.4, -1.3);
// %p42 = (-6, -17);
// %wire_50 = &"TOPPB" @WIRE(mode="straight") {%p42 #"M0":1};
// %p43 = (-6, -2);
// %wire_51 = &"TOPPB" @WIRE(mode="straight") {%p43 #"I0":8};
// %wire_52 = &"TOPPB" @WIRE(mode="straight") {#"I18":32 %p42};
// %wire_53 = &"TOPPB" @WIRE(mode="straight") {%p43 %p42};
// %wire_52 @TEXT("TOPPB", size=1, halign="start", valign="baseline") => @PLACE(-14.6, -16.3);
// %p44 = (47, 15);
// %wire_54 = &"CLKB" @WIRE(mode="straight") {#"I1":3 %p44};
// %wire_54 @TEXT("CLKB", size=1, halign="start", valign="baseline", rotate=90) => @PLACE(46.3, 11.4);
// %p45 = (43, 15);
// %wire_55 = &"CLKAE" @WIRE(mode="straight") {#"I1":1 %p45};
// %wire_55 @TEXT("CLKAE", size=1, halign="start", valign="baseline", rotate=90) => @PLACE(42.3, 11.4);
// %p46 = (67, 3);
// %wire_56 = &"CLKC" @WIRE(mode="straight") {#"I1":5 %p46};
// %p47 = (15, 10);
// %wire_57 = &"CLKC" @WIRE(mode="straight") {#"I0":1 %p47};
// %wire_57 @TEXT("CLKC", size=1, halign="start", valign="baseline", rotate=90) => @PLACE(14.3, 6.4);
// %wire_56 @TEXT("CLKC", size=1, halign="start", valign="baseline") => @PLACE(63.4, 3.7);
// %p48 = (-86, -3);
// %wire_58 = &"AVSS" @WIRE(mode="straight") {%p48 #"I16":5};
// %p49 = (-86, 1);
// %wire_59 = &"AVSS" @WIRE(mode="straight") {%p49 #"I15":5};
// %p50 = (13, -13);
// %wire_60 = &"AVSS" @WIRE(mode="straight") {%p50 #"I0":9};
// %wire_60 @TEXT("AVSS", size=1, halign="end", valign="baseline", rotate=90) => @PLACE(12.3, -9.4);
// %wire_59 @TEXT("AVSS", size=1, halign="end", valign="baseline", rotate=90) => @PLACE(-86.7, 4.6);
// %wire_58 @TEXT("AVSS", size=1, halign="start", valign="baseline", rotate=90) => @PLACE(-86.7, -6.6);
// %p51 = (-86, -30);
// %wire_61 = &"AVDD" @WIRE(mode="straight") {#"I16":3 %p51};
// %p52 = (-86, 28);
// %wire_62 = &"AVDD" @WIRE(mode="straight") {#"I15":3 %p52};
// %p53 = (-10, -27);
// %wire_63 = &"AVDD" @WIRE(mode="straight") {%p53 #"M0":4};
// %p54 = (-10, 25);
// %wire_64 = &"AVDD" @WIRE(mode="straight") {%p54 #"M1":4};
// %p55 = (13, 11);
// %wire_65 = &"AVDD" @WIRE(mode="straight") {#"I0":6 %p55};
// %wire_65 @TEXT("AVDD", size=1, halign="start", valign="baseline", rotate=90) => @PLACE(12.3, 7.4);
// %wire_64 @TEXT("AVDD", size=1, halign="end", valign="baseline") => @PLACE(-6.2, 25.7);
// %wire_63 @TEXT("AVDD", size=1, halign="end", valign="top") => @PLACE(-6.2, -27.7);
// %wire_62 @TEXT("AVDD", size=1, halign="start", valign="baseline", rotate=90) => @PLACE(-86.7, 24.4);
// %wire_61 @TEXT("AVDD", size=1, halign="end", valign="baseline", rotate=90) => @PLACE(-86.7, -26.4);
// $JUNCTION @ATTACH %p3;
// $JUNCTION @ATTACH %p42
// }
ends L3_9bit_SAR_2
