// Explicit saved-library assembly.
simulator lang=spectre
include "L6_SR_latch_1.scs"
