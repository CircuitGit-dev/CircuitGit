// Explicit saved-library assembly.
simulator lang=spectre
include "L6_9bit_REF_Logic.scs"
