// Explicit saved-library assembly.
simulator lang=spectre
include "L5_9bit_Bootstrap.scs"
