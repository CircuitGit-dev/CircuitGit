simulator lang=spectre
// Existing real SAR needs discontinuity handling; no device changes.
rs9N06Options options discontinuity=robust
