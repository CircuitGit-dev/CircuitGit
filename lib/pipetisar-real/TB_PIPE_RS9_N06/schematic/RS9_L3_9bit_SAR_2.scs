// RNL cell 2026_PIPETISAR_RESEARCH/RS9_L3_9bit_SAR_2
// @RNL(type="header") {
//   @VERSION("0.3");
//   @USE-PACKAGE(name="rnl-std-spectre", version="0.3", path="rnl-std-spectre.rnl");
//   @USE-PACKAGE(name="eda-symbol", version="0.1", path="eda-symbol.rnl");
//   @USE-PACKAGE(name="eda-style", version="0.1", path="eda-style.rnl")
// }
subckt RS9_L3_9bit_SAR_2 AVDD AVSS CLKA CLKAE CLKB CLKC CLKD D_9 D_8 D_7 \
        D_6 D_5 D_4 D_3 D_2 D_1 D_0 DONE DVDD DVSS TOPNB TOPPB VBSTN VBSTP \
        VCALB VCM VINN VINP VREFN VREFP
    M1 (TOPNB CLKAEB VCM AVDD) pch_lvt_mac l=30n w=4u multi=3 nf=8 sd=100n \
        ad=2e-13 as=2.25e-13 pd=4.8u ps=5.9u nrd=0.057867 nrs=0.057867 \
        sa=295.835n sb=295.835n sa1=149.315n sa2=274.565n sa3=507.343n \
        sa4=281.096n sb1=149.315n sb2=274.565n sb3=507.343n spa=100n \
        spa1=100n spa2=100n spa3=100n sap=142.36n sapb=158.808n \
        spba=115.715n spba1=117.043n dfm_flag=0 spmt=1.11111e+15 spomt=0 \
        spomt1=1.11111e+60 spmb=1.11111e+15 spomb=0 spomb1=1.11111e+60
    M0 (TOPPB CLKAEB VCM AVDD) pch_lvt_mac l=30n w=4u multi=3 nf=8 sd=100n \
        ad=2e-13 as=2.25e-13 pd=4.8u ps=5.9u nrd=0.057867 nrs=0.057867 \
        sa=295.835n sb=295.835n sa1=149.315n sa2=274.565n sa3=507.343n \
        sa4=281.096n sb1=149.315n sb2=274.565n sb3=507.343n spa=100n \
        spa1=100n spa2=100n spa3=100n sap=142.36n sapb=158.808n \
        spba=115.715n spba1=117.043n dfm_flag=0 spmt=1.11111e+15 spomt=0 \
        spomt1=1.11111e+60 spmb=1.11111e+15 spomb=0 spomb1=1.11111e+60
    I16 (CLKA VBSTP AVDD VINP AVSS) RS9_L5_9bit_Bootstrap
    I15 (CLKA VBSTN AVDD VINN AVSS) RS9_L5_9bit_Bootstrap
    I0 (CLKC COMPN COMPP VCALB VCM AVDD TOPNB TOPPB AVSS) \
        RS9_L5_9bit_Comparator_LN
    I1 (CLKAE CLKAEB CLKB CLKB_B CLKC CLKD COMPN COMPP D_9 D_8 D_7 D_6 D_5 \
        D_4 D_3 D_2 D_1 D_0 DN_9 DN_8 DN_7 DN_6 DN_5 DN_4 DN_3 DN_2 DN_1 \
        DN_0 DONE DP_9 DP_8 DP_7 DP_6 DP_5 DP_4 DP_3 DP_2 DP_1 DP_0 RNN_9 \
        RNN_8 RNN_7 RNN_6 RNN_5 RNN_4 RNN_3 RNN_2 RNN_1 RNP_9 RNP_8 RNP_7 \
        RNP_6 RNP_5 RNP_4 RNP_3 RNP_2 RNP_1 RPN_9 RPN_8 RPN_7 RPN_6 RPN_5 \
        RPN_4 RPN_3 RPN_2 RPN_1 RPP_9 RPP_8 RPP_7 RPP_6 RPP_5 RPP_4 RPP_3 \
        RPP_2 RPP_1 DVDD DVSS) RS9_L5_9bit_SAR_Logic_1
    I17 (BOTN_9 BOTN_8 BOTN_7 BOTN_6 BOTN_5 BOTN_4 BOTN_3 BOTN_2 BOTN_1 \
        BOTN_0 CLKB_B DVDD DVSS RNN_9 RNN_8 RNN_7 RNN_6 RNN_5 RNN_4 RNN_3 \
        RNN_2 RNN_1 RPN_9 RPN_8 RPN_7 RPN_6 RPN_5 RPN_4 RPN_3 RPN_2 RPN_1 \
        TOPNB VBSTN VINN VREFN VREFP) RS9_L5_9bit_RSW_CDAC
    I18 (BOTP_9 BOTP_8 BOTP_7 BOTP_6 BOTP_5 BOTP_4 BOTP_3 BOTP_2 BOTP_1 \
        BOTP_0 CLKB_B DVDD DVSS RNP_9 RNP_8 RNP_7 RNP_6 RNP_5 RNP_4 RNP_3 \
        RNP_2 RNP_1 RPP_9 RPP_8 RPP_7 RPP_6 RPP_5 RPP_4 RPP_3 RPP_2 RPP_1 \
        TOPPB VBSTP VINP VREFN VREFP) RS9_L5_9bit_RSW_CDAC
// @RNL(author="rnl-virtuoso") {
//   %block_symbol = @DEFINE-SYMBOL(box=[0, -99.2, 86.4, 4.8]) {
//     @RECTANGLE {(0, -99.2) (86.4, 4.8)};
//     (43.2, 10.4) @TEXT("TRANSISTOR SAR", size=4.6, halign="middle", valign="middle");
//     ? @TEXT("${name}", size=3.8, halign="middle", valign="middle", key="name") => @PLACE(43.2, -104.3);
//     (0, 0) @PIN(terminal="VINN");
//     (2.2, 0) @TEXT("VINN", size=3.8, halign="start", valign="middle");
//     (0, -12.8) @PIN(terminal="VINP");
//     (2.2, -12.8) @TEXT("VINP", size=3.8, halign="start", valign="middle");
//     (0, -38.4) @PIN(terminal="VREFP");
//     (2.2, -38.4) @TEXT("VREFP", size=3.8, halign="start", valign="middle");
//     (0, -46.4) @PIN(terminal="VREFN");
//     (2.2, -46.4) @TEXT("VREFN", size=3.8, halign="start", valign="middle");
//     (0, -54.4) @PIN(terminal="VCALB");
//     (2.2, -54.4) @TEXT("VCALB", size=3.8, halign="start", valign="middle");
//     (0, -62.4) @PIN(terminal="VCM");
//     (2.2, -62.4) @TEXT("VCM", size=3.8, halign="start", valign="middle");
//     (0, -70.4) @PIN(terminal="AVDD");
//     (2.2, -70.4) @TEXT("AVDD", size=3.8, halign="start", valign="middle");
//     (0, -78.4) @PIN(terminal="DVDD");
//     (2.2, -78.4) @TEXT("DVDD", size=3.8, halign="start", valign="middle");
//     (0, -86.4) @PIN(terminal="AVSS");
//     (2.2, -86.4) @TEXT("AVSS", size=3.8, halign="start", valign="middle");
//     (0, -94.4) @PIN(terminal="DVSS");
//     (2.2, -94.4) @TEXT("DVSS", size=3.8, halign="start", valign="middle");
//     (86.4, 0) @PIN(terminal=["D_9", "D_8", "D_7", "D_6", "D_5", "D_4", "D_3", "D_2", "D_1", "D_0"]);
//     (84.2, 0) @TEXT("D<9:0>", size=3.8, halign="end", valign="middle");
//     (86.4, -8) @PIN(terminal="DONE");
//     (84.2, -8) @TEXT("DONE", size=3.8, halign="end", valign="middle");
//     (86.4, -16) @PIN(terminal="CLKC");
//     (84.2, -16) @TEXT("CLKC", size=3.8, halign="end", valign="middle");
//     (86.4, -32) @PIN(terminal="CLKA");
//     (84.2, -32) @TEXT("CLKA", size=3.8, halign="end", valign="middle");
//     (86.4, -40) @PIN(terminal="CLKAE");
//     (84.2, -40) @TEXT("CLKAE", size=3.8, halign="end", valign="middle");
//     (86.4, -48) @PIN(terminal="CLKB");
//     (84.2, -48) @TEXT("CLKB", size=3.8, halign="end", valign="middle");
//     (86.4, -56) @PIN(terminal="CLKD");
//     (84.2, -56) @TEXT("CLKD", size=3.8, halign="end", valign="middle");
//     (86.4, -70.4) @PIN(terminal="TOPPB");
//     (84.2, -70.4) @TEXT("TOPPB", size=3.8, halign="end", valign="middle");
//     (86.4, -78.4) @PIN(terminal="TOPNB");
//     (84.2, -78.4) @TEXT("TOPNB", size=3.8, halign="end", valign="middle");
//     (86.4, -86.4) @PIN(terminal="VBSTP");
//     (84.2, -86.4) @TEXT("VBSTP", size=3.8, halign="end", valign="middle");
//     (86.4, -94.4) @PIN(terminal="VBSTN");
//     (84.2, -94.4) @TEXT("VBSTN", size=3.8, halign="end", valign="middle")
//   };
//   # @SET-SYMBOL %block_symbol;
//   %symbol_0 = @DEFINE-SYMBOL(box=[-0.1, -2.8, 3.8, 2.8]) {
//     @LINE {(0, 0) (0.7, 0)};
//     @LINE {(1.5, 1.5) (1.5, -1.5)};
//     @LINE {(2, -1.5) (4, -1.5) (4, -3)};
//     @LINE {(2, 1.5) (4, 1.5) (4, 3)};
//     (1.1, 0) @CIRCLE(radius=0.4);
//     @LINE {(3.7, 2) (2.7, 1.5) (3.7, 1)};
//     @LINE {(2, -1.5) (2, 1.5)};
//     ? @TEXT("${name}", size=0.8, halign="start", valign="baseline", key="name") => @PLACE(4.9, 3.4);
//     ? @TEXT("${model}", size=0.8, halign="end", valign="baseline", key="model") => @PLACE(3.3, 3.2);
//     (4, 3) @PIN(terminal=3);
//     (4, 1) @PIN(terminal=4);
//     (0, 0) @PIN(terminal=2);
//     (4, -3) @PIN(terminal=1)
//   };
//   #"M1" @SET-SYMBOL %symbol_0;
//   #"M1" @PLACE(-2, 24) => @ORIENT("MY");
//   #"M0" @SET-SYMBOL %symbol_0;
//   #"M0" @PLACE(-2, -26) => @ORIENT("R180");
//   #"I0" @PLACE(6, 0) => @ORIENT("R0");
//   #"I16" @PLACE(-99, -17) => @ORIENT("MX");
//   #"I1" @PLACE(29, 2) => @ORIENT("R0");
//   #"I18" @PLACE(-55, -17) => @ORIENT("R0");
//   #"I15" @PLACE(-99, 15) => @ORIENT("R0");
//   #"I17" @PLACE(-55, 15) => @ORIENT("MX");
//   %marker_1 = (-15, 17);
//   $FIGURE @ATTACH %marker_1 => @SET-SYMBOL $NO_CONNECT_SYMBOL => @ORIENT("R90");
//   %marker_12 = (67, 1);
//   $FIGURE @ATTACH %marker_12 => @SET-SYMBOL $NO_CONNECT_SYMBOL => @ORIENT("R90");
//   %marker_28 = (67, -1);
//   $FIGURE @ATTACH %marker_28 => @SET-SYMBOL $NO_CONNECT_SYMBOL => @ORIENT("R90");
//   %marker_38 = (-15, -19);
//   $FIGURE @ATTACH %marker_38 => @SET-SYMBOL $NO_CONNECT_SYMBOL => @ORIENT("R90");
//   %port_0 = $IO_PORT @ATTACH &"AVDD" => @PLACE(-116, 32) => @ORIENT("R0");
//   %port_1 = $IO_PORT @ATTACH &"AVSS" => @PLACE(-116, 29) => @ORIENT("R0");
//   %port_2 = $IO_PORT @ATTACH &"DVDD" => @PLACE(-116, 26) => @ORIENT("R0");
//   %port_3 = $IO_PORT @ATTACH &"DVSS" => @PLACE(-116, 23) => @ORIENT("R0");
//   %port_4 = $IO_PORT @ATTACH &"VCM" => @PLACE(-116, 20) => @ORIENT("R0");
//   %input_port_symbol = @DEFINE-SYMBOL(box=[-2, -1, 0, 1]) {
//       @LINE(fill="linecolor", linestyle="none") {(-2, -0.9) (-2, 0.9) (-0.9, 0.9) (0, 0) (-0.9, -0.9) (-2, -0.9)};
//       (0, 0) @PIN(terminal=1, direction="right");
//       ? @TEXT("${name}", key="name", halign="middle") => @PLACE(-1, 1.6)
//     };
//   %port_5 = $IO_PORT @ATTACH &"CLKA" => @PLACE(-115, 14) => @ORIENT("R0");
//   %port_5 @SET-SYMBOL %input_port_symbol;
//   %port_5 @TEXT("CLKA", key="name");
//   %port_6 = $IO_PORT @ATTACH &"CLKAE" => @PLACE(-115, 11) => @ORIENT("R0");
//   %port_6 @SET-SYMBOL %input_port_symbol;
//   %port_6 @TEXT("CLKAE", key="name");
//   %port_7 = $IO_PORT @ATTACH &"CLKB" => @PLACE(-115, 8) => @ORIENT("R0");
//   %port_7 @SET-SYMBOL %input_port_symbol;
//   %port_7 @TEXT("CLKB", key="name");
//   %output_port_symbol = @DEFINE-SYMBOL(box=[0, -1, 2, 1]) {
//       @LINE(fill="linecolor", linestyle="none") {(0, -0.9) (0, 0.9) (1.1, 0.9) (2, 0) (1.1, -0.9) (0, -0.9)};
//       (0, 0) @PIN(terminal=1, direction="left");
//       ? @TEXT("${name}", key="name", halign="middle") => @PLACE(1, 1.6)
//     };
//   %port_8 = $IO_PORT @ATTACH &"VBSTP" => @PLACE(-117, -10) => @ORIENT("R0");
//   %port_8 @SET-SYMBOL %output_port_symbol;
//   %port_8 @TEXT("VBSTP", key="name");
//   %port_9 = $IO_PORT @ATTACH &"VREFP" => @PLACE(-116, 5) => @ORIENT("R0");
//   %port_10 = $IO_PORT @ATTACH &"VREFN" => @PLACE(-116, 2) => @ORIENT("R0");
//   %port_11 = $IO_PORT @ATTACH &"VINN" => @PLACE(-115, -1) => @ORIENT("R0");
//   %port_11 @SET-SYMBOL %input_port_symbol;
//   %port_11 @TEXT("VINN", key="name");
//   %port_12 = $IO_PORT @ATTACH &"VINP" => @PLACE(-115, -4) => @ORIENT("R0");
//   %port_12 @SET-SYMBOL %input_port_symbol;
//   %port_12 @TEXT("VINP", key="name");
//   %bus_port_type_13 = @DEFINE(roles=[["p", "net"], ["p1", "net"], ["p2", "net"], ["p3", "net"], ["p4", "net"], ["p5", "net"], ["p6", "net"], ["p7", "net"], ["p8", "net"], ["p9", "net"]]) {};
//   %bus_port_type_13_symbol = @DEFINE-SYMBOL {(0, 0) @PIN(terminal=[1, 2, 3, 4, 5, 6, 7, 8, 9, 10])};
//   {&"D_9" &"D_8" &"D_7" &"D_6" &"D_5" &"D_4" &"D_3" &"D_2" &"D_1" &"D_0"} @REMOVE-FROM $PORT_FILL_SET;
//   %port_13 = %bus_port_type_13 @ATTACH &"D_9" &"D_8" &"D_7" &"D_6" &"D_5" &"D_4" &"D_3" &"D_2" &"D_1" &"D_0" => @PLACE(-116, -7) => @ORIENT("R0");
//   %port_13 @SET-SYMBOL %bus_port_type_13_symbol;
//   %port_13_marker = $IO_PORT @ATTACH &"D_9" => @PLACE(-116, -7) => @ORIENT("R0");
//   %port_13_marker @TEXT("D<9:0>", key="name");
//   %port_14 = $IO_PORT @ATTACH &"VCALB" => @PLACE(-116, 17) => @ORIENT("R0");
//   %port_15 = $IO_PORT @ATTACH &"VBSTN" => @PLACE(-117, -13) => @ORIENT("R0");
//   %port_15 @SET-SYMBOL %output_port_symbol;
//   %port_15 @TEXT("VBSTN", key="name");
//   %port_16 = $IO_PORT @ATTACH &"TOPNB" => @PLACE(-116, -19) => @ORIENT("R0");
//   %port_17 = $IO_PORT @ATTACH &"DONE" => @PLACE(-112, -44) => @ORIENT("R0");
//   %port_17 @SET-SYMBOL %output_port_symbol;
//   %port_17 @TEXT("DONE", key="name");
//   %port_18 = $IO_PORT @ATTACH &"TOPPB" => @PLACE(-116, -16) => @ORIENT("R0");
//   %port_19 = $IO_PORT @ATTACH &"CLKD" => @PLACE(-115, -22) => @ORIENT("R0");
//   %port_19 @SET-SYMBOL %input_port_symbol;
//   %port_19 @TEXT("CLKD", key="name");
//   %port_20 = $IO_PORT @ATTACH &"CLKC" => @PLACE(-112, -60) => @ORIENT("R0");
//   %port_20 @SET-SYMBOL %output_port_symbol;
//   %port_20 @TEXT("CLKC", key="name");
//   %p0 = (67, -13);
//   %wire_0 = &"CLKAEB" @WIRE(mode="straight") {#"I1":2 %p0};
//   %p1 = (3, -26);
//   %wire_1 = &"CLKAEB" @WIRE(mode="straight") {#"M0":2 %p1};
//   %p2 = (3, 24);
//   %wire_2 = &"CLKAEB" @WIRE(mode="straight") {#"M1":2 %p2};
//   %wire_2 @TEXT("CLKAEB", size=1, halign="middle", valign="baseline") => @PLACE(1, 24.7);
//   %wire_1 @TEXT("CLKAEB", size=1, halign="middle", valign="top") => @PLACE(1, -26.7);
//   %wire_0 @TEXT("CLKAEB", size=1, halign="start", valign="baseline") => @PLACE(63.4, -12.3);
//   %p3 = (-6, 15);
//   %wire_3 = &"TOPNB" @WIRE(mode="straight") {%p3 #"M1":1};
//   %p4 = (-6, 0);
//   %wire_4 = &"TOPNB" @WIRE(mode="straight") {%p4 #"I0":7};
//   %wire_5 = &"TOPNB" @WIRE(mode="straight") {#"I17":32 %p3};
//   %wire_6 = &"TOPNB" @WIRE(mode="straight") {%p4 %p3};
//   %wire_5 @TEXT("TOPNB", size=1, halign="start", valign="top") => @PLACE(-14.6, 14.3);
//   %p5 = (-35, -37);
//   %wire_7 = &"CLKB_B" @WIRE(mode="straight") {%p5 #"I18":11};
//   %p6 = (-35, 35);
//   %wire_8 = &"CLKB_B" @WIRE(mode="straight") {#"I17":11 %p6};
//   %p7 = (67, 5);
//   %wire_9 = &"CLKB_B" @WIRE(mode="straight") {#"I1":4 %p7};
//   %wire_9 @TEXT("CLKB\_B", size=1, halign="start", valign="baseline") => @PLACE(63.4, 5.7);
//   %wire_8 @TEXT("CLKB\_B", size=1, halign="start", valign="baseline", rotate=90) => @PLACE(-35.7, 31.4);
//   %wire_7 @TEXT("CLKB\_B", size=1, halign="end", valign="baseline", rotate=90) => @PLACE(-35.7, -33.4);
//   %p8 = (47, -23);
//   %wire_10 = &"CLKD" @WIRE(mode="straight") {%p8 #"I1":6};
//   %wire_10 @TEXT("CLKD", size=1, halign="end", valign="baseline", rotate=90) => @PLACE(46.3, -19.4);
//   %wire_11 = {&"DN_9" &"DN_8" &"DN_7" &"DN_6" &"DN_5" &"DN_4" &"DN_3" &"DN_2" &"DN_1" &"DN_0"} @WIRE(mode="straight") {#"I1":19 %marker_12};
//   %wire_11 @TEXT("DN<9:0>", size=1, halign="start", valign="baseline") => @PLACE(63.4, 2.2);
//   %wire_12 = {&"DP_9" &"DP_8" &"DP_7" &"DP_6" &"DP_5" &"DP_4" &"DP_3" &"DP_2" &"DP_1" &"DP_0"} @WIRE(mode="straight") {#"I1":30 %marker_28};
//   %wire_12 @TEXT("DP<9:0>", size=1, halign="start", valign="baseline") => @PLACE(63.4, 0.2);
//   %p9 = (67, -9);
//   %wire_13 = {&"RPP_9" &"RPP_8" &"RPP_7" &"RPP_6" &"RPP_5" &"RPP_4" &"RPP_3" &"RPP_2" &"RPP_1"} @WIRE(mode="straight") {#"I1":67 %p9};
//   %p10 = (-59, -19);
//   %wire_14 = {&"RPP_9" &"RPP_8" &"RPP_7" &"RPP_6" &"RPP_5" &"RPP_4" &"RPP_3" &"RPP_2" &"RPP_1"} @WIRE(mode="straight") {%p10 #"I18":23};
//   %wire_14 @TEXT("RPP<9:1>", size=1, halign="end", valign="baseline") => @PLACE(-55.4, -17.8);
//   %wire_13 @TEXT("RPP<9:1>", size=1, halign="start", valign="baseline") => @PLACE(63.4, -7.8);
//   %p11 = (-59, 17);
//   %wire_15 = {&"RPN_9" &"RPN_8" &"RPN_7" &"RPN_6" &"RPN_5" &"RPN_4" &"RPN_3" &"RPN_2" &"RPN_1"} @WIRE(mode="straight") {%p11 #"I17":23};
//   %p12 = (67, -5);
//   %wire_16 = {&"RPN_9" &"RPN_8" &"RPN_7" &"RPN_6" &"RPN_5" &"RPN_4" &"RPN_3" &"RPN_2" &"RPN_1"} @WIRE(mode="straight") {#"I1":58 %p12};
//   %wire_16 @TEXT("RPN<9:1>", size=1, halign="start", valign="baseline") => @PLACE(63.4, -3.8);
//   %wire_15 @TEXT("RPN<9:1>", size=1, halign="end", valign="baseline") => @PLACE(-55.4, 18.2);
//   %p13 = (67, -11);
//   %wire_17 = {&"RNP_9" &"RNP_8" &"RNP_7" &"RNP_6" &"RNP_5" &"RNP_4" &"RNP_3" &"RNP_2" &"RNP_1"} @WIRE(mode="straight") {#"I1":49 %p13};
//   %p14 = (-59, -17);
//   %wire_18 = {&"RNP_9" &"RNP_8" &"RNP_7" &"RNP_6" &"RNP_5" &"RNP_4" &"RNP_3" &"RNP_2" &"RNP_1"} @WIRE(mode="straight") {%p14 #"I18":14};
//   %wire_18 @TEXT("RNP<9:1>", size=1, halign="end", valign="baseline") => @PLACE(-55.4, -15.8);
//   %wire_17 @TEXT("RNP<9:1>", size=1, halign="start", valign="baseline") => @PLACE(63.4, -9.8);
//   %p15 = (-59, 15);
//   %wire_19 = {&"RNN_9" &"RNN_8" &"RNN_7" &"RNN_6" &"RNN_5" &"RNN_4" &"RNN_3" &"RNN_2" &"RNN_1"} @WIRE(mode="straight") {%p15 #"I17":14};
//   %p16 = (67, -7);
//   %wire_20 = {&"RNN_9" &"RNN_8" &"RNN_7" &"RNN_6" &"RNN_5" &"RNN_4" &"RNN_3" &"RNN_2" &"RNN_1"} @WIRE(mode="straight") {#"I1":40 %p16};
//   %wire_20 @TEXT("RNN<9:1>", size=1, halign="start", valign="baseline") => @PLACE(63.4, -5.8);
//   %wire_19 @TEXT("RNN<9:1>", size=1, halign="end", valign="baseline") => @PLACE(-55.4, 16.2);
//   %wire_21 = {&"BOTN_9" &"BOTN_8" &"BOTN_7" &"BOTN_6" &"BOTN_5" &"BOTN_4" &"BOTN_3" &"BOTN_2" &"BOTN_1" &"BOTN_0"} @WIRE(mode="straight") {#"I17":1 %marker_1};
//   %wire_21 @TEXT("BOTN<9:0>", size=1, halign="start", valign="baseline") => @PLACE(-18.6, 18.2);
//   %wire_22 = {&"BOTP_9" &"BOTP_8" &"BOTP_7" &"BOTP_6" &"BOTP_5" &"BOTP_4" &"BOTP_3" &"BOTP_2" &"BOTP_1" &"BOTP_0"} @WIRE(mode="straight") {#"I18":1 %marker_38};
//   %wire_22 @TEXT("BOTP<9:0>", size=1, halign="start", valign="baseline") => @PLACE(-18.6, -20.8);
//   %p17 = (2, 3);
//   %wire_23 = &"VCALB" @WIRE(mode="straight") {%p17 #"I0":4};
//   %wire_23 @TEXT("VCALB", size=1, halign="end", valign="baseline") => @PLACE(5.6, 3.7);
//   %p18 = (67, -3);
//   %wire_24 = {&"D_9" &"D_8" &"D_7" &"D_6" &"D_5" &"D_4" &"D_3" &"D_2" &"D_1" &"D_0"} @WIRE(mode="straight") {#"I1":9 %p18};
//   %wire_24 @TEXT("D<9:0>", size=1, halign="start", valign="baseline") => @PLACE(63.4, -1.8);
//   %p19 = (-37, 0);
//   %wire_25 = &"VREFP" @WIRE(mode="straight") {%p19 #"I17":36};
//   %p20 = (-37, -2);
//   %wire_26 = &"VREFP" @WIRE(mode="straight") {#"I18":36 %p20};
//   %wire_26 @TEXT("VREFP", size=1, halign="start", valign="baseline", rotate=90) => @PLACE(-37.7, -5.6);
//   %wire_25 @TEXT("VREFP", size=1, halign="end", valign="baseline", rotate=90) => @PLACE(-37.7, 3.6);
//   %p21 = (-37, 35);
//   %wire_27 = &"VREFN" @WIRE(mode="straight") {#"I17":35 %p21};
//   %p22 = (-37, -37);
//   %wire_28 = &"VREFN" @WIRE(mode="straight") {%p22 #"I18":35};
//   %wire_28 @TEXT("VREFN", size=1, halign="end", valign="baseline", rotate=90) => @PLACE(-37.7, -33.4);
//   %wire_27 @TEXT("VREFN", size=1, halign="start", valign="baseline", rotate=90) => @PLACE(-37.7, 31.4);
//   %p23 = (-103, -17);
//   %wire_29 = &"VINP" @WIRE(mode="straight") {%p23 #"I16":4};
//   %p24 = (-59, -21);
//   %wire_30 = &"VINP" @WIRE(mode="straight") {%p24 #"I18":34};
//   %wire_30 @TEXT("VINP", size=1, halign="end", valign="baseline") => @PLACE(-55.4, -20.3);
//   %wire_29 @TEXT("VINP", size=1, halign="end", valign="top") => @PLACE(-99.4, -17.7);
//   %p25 = (-59, 19);
//   %wire_31 = &"VINN" @WIRE(mode="straight") {%p25 #"I17":34};
//   %p26 = (-103, 15);
//   %wire_32 = &"VINN" @WIRE(mode="straight") {%p26 #"I15":4};
//   %wire_32 @TEXT("VINN", size=1, halign="end", valign="baseline") => @PLACE(-99.4, 15.7);
//   %wire_31 @TEXT("VINN", size=1, halign="end", valign="baseline") => @PLACE(-55.4, 19.7);
//   %p27 = (-6, -33);
//   %wire_33 = &"VCM" @WIRE(mode="straight") {#"M0":3 %p27};
//   %p28 = (-6, 31);
//   %wire_34 = &"VCM" @WIRE(mode="straight") {#"M1":3 %p28};
//   %p29 = (2, -5);
//   %wire_35 = &"VCM" @WIRE(mode="straight") {%p29 #"I0":5};
//   %wire_35 @TEXT("VCM", size=1, halign="end", valign="baseline") => @PLACE(5.6, -4.3);
//   %wire_34 @TEXT("VCM", size=1, halign="middle", valign="baseline", rotate=90) => @PLACE(-6.7, 29);
//   %wire_33 @TEXT("VCM", size=1, halign="middle", valign="baseline", rotate=90) => @PLACE(-6.7, -31);
//   %p30 = (-84, -30);
//   %wire_36 = &"CLKA" @WIRE(mode="straight") {#"I16":1 %p30};
//   %p31 = (-84, 28);
//   %wire_37 = &"CLKA" @WIRE(mode="straight") {#"I15":1 %p31};
//   %wire_37 @TEXT("CLKA", size=1, halign="start", valign="baseline", rotate=90) => @PLACE(-84.7, 24.4);
//   %wire_36 @TEXT("CLKA", size=1, halign="end", valign="baseline", rotate=90) => @PLACE(-84.7, -26.4);
//   %p32 = (-67, -17);
//   %wire_38 = &"VBSTP" @WIRE(mode="straight") {#"I16":2 %p32};
//   %p33 = (-35, -2);
//   %wire_39 = &"VBSTP" @WIRE(mode="straight") {#"I18":33 %p33};
//   %wire_39 @TEXT("VBSTP", size=1, halign="start", valign="baseline", rotate=90) => @PLACE(-35.7, -5.6);
//   %wire_38 @TEXT("VBSTP", size=1, halign="start", valign="top") => @PLACE(-70.6, -17.7);
//   %p34 = (-67, 15);
//   %wire_40 = &"VBSTN" @WIRE(mode="straight") {#"I15":2 %p34};
//   %p35 = (-35, 0);
//   %wire_41 = &"VBSTN" @WIRE(mode="straight") {%p35 #"I17":33};
//   %wire_41 @TEXT("VBSTN", size=1, halign="end", valign="baseline", rotate=90) => @PLACE(-35.7, 3.6);
//   %wire_40 @TEXT("VBSTN", size=1, halign="start", valign="baseline") => @PLACE(-70.6, 15.7);
//   %p36 = (-105.6, -44);
//   %wire_42 = &"DONE" @WIRE(mode="straight") {%port_17:p %p36};
//   %p37 = (63, -31.2);
//   %wire_43 = &"DONE" @WIRE(mode="straight") {%p37 #"I1":29};
//   %wire_42 @TEXT("DONE", size=1.9, halign="start", valign="baseline") => @PLACE(-108.8, -44);
//   %wire_43 @TEXT("DONE", size=1.9, halign="middle", valign="baseline") => @PLACE(63, -29.6);
//   %p38 = (-39, 35);
//   %wire_44 = &"DVSS" @WIRE(mode="straight") {#"I17":13 %p38};
//   %p39 = (45, -23);
//   %wire_45 = &"DVSS" @WIRE(mode="straight") {%p39 #"I1":77};
//   %p40 = (-39, -37);
//   %wire_46 = &"DVSS" @WIRE(mode="straight") {%p40 #"I18":13};
//   %wire_46 @TEXT("DVSS", size=1, halign="end", valign="baseline", rotate=90) => @PLACE(-39.7, -33.4);
//   %wire_45 @TEXT("DVSS", size=1, halign="end", valign="baseline", rotate=90) => @PLACE(44.3, -19.4);
//   %wire_44 @TEXT("DVSS", size=1, halign="start", valign="baseline", rotate=90) => @PLACE(-39.7, 31.4);
//   %p41 = (-39, 0);
//   %wire_47 = &"DVDD" @WIRE(mode="straight") {%p41 #"I17":12};
//   %p42 = (45, 15);
//   %wire_48 = &"DVDD" @WIRE(mode="straight") {#"I1":76 %p42};
//   %p43 = (-39, -2);
//   %wire_49 = &"DVDD" @WIRE(mode="straight") {#"I18":12 %p43};
//   %wire_49 @TEXT("DVDD", size=1, halign="start", valign="baseline", rotate=90) => @PLACE(-39.7, -5.6);
//   %wire_48 @TEXT("DVDD", size=1, halign="start", valign="baseline", rotate=90) => @PLACE(44.3, 11.4);
//   %wire_47 @TEXT("DVDD", size=1, halign="end", valign="baseline", rotate=90) => @PLACE(-39.7, 3.6);
//   %wire_50 = &"COMPP" @WIRE(mode="straight") {#"I0":3 #"I1":8};
//   %wire_50 @TEXT("COMPP", size=1, halign="start", valign="baseline") => @PLACE(22.4, 0.7);
//   %wire_51 = &"COMPN" @WIRE(mode="straight") {#"I0":2 #"I1":7};
//   %wire_51 @TEXT("COMPN", size=1, halign="start", valign="baseline") => @PLACE(22.4, -1.3);
//   %p44 = (-6, -17);
//   %wire_52 = &"TOPPB" @WIRE(mode="straight") {%p44 #"M0":1};
//   %p45 = (-6, -2);
//   %wire_53 = &"TOPPB" @WIRE(mode="straight") {%p45 #"I0":8};
//   %wire_54 = &"TOPPB" @WIRE(mode="straight") {#"I18":32 %p44};
//   %wire_55 = &"TOPPB" @WIRE(mode="straight") {%p45 %p44};
//   %wire_54 @TEXT("TOPPB", size=1, halign="start", valign="baseline") => @PLACE(-14.6, -16.3);
//   %p46 = (47, 15);
//   %wire_56 = &"CLKB" @WIRE(mode="straight") {#"I1":3 %p46};
//   %wire_56 @TEXT("CLKB", size=1, halign="start", valign="baseline", rotate=90) => @PLACE(46.3, 11.4);
//   %p47 = (43, 15);
//   %wire_57 = &"CLKAE" @WIRE(mode="straight") {#"I1":1 %p47};
//   %wire_57 @TEXT("CLKAE", size=1, halign="start", valign="baseline", rotate=90) => @PLACE(42.3, 11.4);
//   %p48 = (67, 3);
//   %wire_58 = &"CLKC" @WIRE(mode="straight") {#"I1":5 %p48};
//   %p49 = (15, 10);
//   %wire_59 = &"CLKC" @WIRE(mode="straight") {#"I0":1 %p49};
//   %p50 = (-105.6, -60);
//   %wire_60 = &"CLKC" @WIRE(mode="straight") {%port_20:p %p50};
//   %wire_60 @TEXT("CLKC", size=1.9, halign="start", valign="baseline") => @PLACE(-108.8, -60);
//   %wire_59 @TEXT("CLKC", size=1, halign="start", valign="baseline", rotate=90) => @PLACE(14.3, 6.4);
//   %wire_58 @TEXT("CLKC", size=1, halign="start", valign="baseline") => @PLACE(63.4, 3.7);
//   %p51 = (-86, -3);
//   %wire_61 = &"AVSS" @WIRE(mode="straight") {%p51 #"I16":5};
//   %p52 = (-86, 1);
//   %wire_62 = &"AVSS" @WIRE(mode="straight") {%p52 #"I15":5};
//   %p53 = (13, -13);
//   %wire_63 = &"AVSS" @WIRE(mode="straight") {%p53 #"I0":9};
//   %wire_63 @TEXT("AVSS", size=1, halign="end", valign="baseline", rotate=90) => @PLACE(12.3, -9.4);
//   %wire_62 @TEXT("AVSS", size=1, halign="end", valign="baseline", rotate=90) => @PLACE(-86.7, 4.6);
//   %wire_61 @TEXT("AVSS", size=1, halign="start", valign="baseline", rotate=90) => @PLACE(-86.7, -6.6);
//   %p54 = (-86, -30);
//   %wire_64 = &"AVDD" @WIRE(mode="straight") {#"I16":3 %p54};
//   %p55 = (-86, 28);
//   %wire_65 = &"AVDD" @WIRE(mode="straight") {#"I15":3 %p55};
//   %p56 = (-10, -27);
//   %wire_66 = &"AVDD" @WIRE(mode="straight") {%p56 #"M0":4};
//   %p57 = (-10, 25);
//   %wire_67 = &"AVDD" @WIRE(mode="straight") {%p57 #"M1":4};
//   %p58 = (13, 11);
//   %wire_68 = &"AVDD" @WIRE(mode="straight") {#"I0":6 %p58};
//   %wire_68 @TEXT("AVDD", size=1, halign="start", valign="baseline", rotate=90) => @PLACE(12.3, 7.4);
//   %wire_67 @TEXT("AVDD", size=1, halign="end", valign="baseline") => @PLACE(-6.2, 25.7);
//   %wire_66 @TEXT("AVDD", size=1, halign="end", valign="top") => @PLACE(-6.2, -27.7);
//   %wire_65 @TEXT("AVDD", size=1, halign="start", valign="baseline", rotate=90) => @PLACE(-86.7, 24.4);
//   %wire_64 @TEXT("AVDD", size=1, halign="end", valign="baseline", rotate=90) => @PLACE(-86.7, -26.4);
//   $JUNCTION @ATTACH %p3;
//   $JUNCTION @ATTACH %p44;
//   (-88, -51) @TEXT("Original transistor SAR. Added high-impedance DONE/CLKC observation pins only.", size=2.7, halign="start", valign="baseline")
// }
ends RS9_L3_9bit_SAR_2
