// RNL cell 2026_PIPETISAR_RESEARCH/L4_stage1_flash_bootstrapper
// @RNL(type="header") {
//   @VERSION("0.3");
//   @USE-PACKAGE(name="rnl-std-spectre", version="0.3", path="rnl-std-spectre.rnl");
//   @USE-PACKAGE(name="eda-symbol", version="0.1", path="eda-symbol.rnl");
//   @USE-PACKAGE(name="eda-style", version="0.1", path="eda-style.rnl")
// }
subckt L4_stage1_flash_bootstrapper CLKN VBSTN VBSTP VDD VINN VINP VSS
    C3 (net37 net38) cfmom_2t nr=26 lr=2.5u w=50n s=50n stm=2 spm=7 \
        multi=1
    C2 (net39 net40) cfmom_2t nr=26 lr=2.5u w=50n s=50n stm=2 spm=7 \
        multi=1
    C0 (net39 net40) cfmom_2t nr=28 lr=2.5u w=50n s=50n stm=3 spm=7 \
        multi=1
    C1 (net37 net38) cfmom_2t nr=28 lr=2.5u w=50n s=50n stm=3 spm=7 \
        multi=1
    M1 (net42 VBSTP net40 VSS) nch_ulvt_mac l=30n w=250.0n multi=1 nf=1 \
        sd=100n ad=1.875e-14 as=1.875e-14 pd=650.0n ps=650.0n nrd=1.338763 \
        nrs=1.338763 sa=75.0n sb=75.0n sa1=75.0n sa2=75.0n sa3=75.0n \
        sa4=75.0n sb1=75.0n sb2=75.0n sb3=75.0n spa=100n spa1=100n \
        spa2=100n spa3=100n sap=91.9776n sapb=114.444n spba=115.715n \
        spba1=117.043n dfm_flag=0 spmt=1.11111e+15 spomt=0 \
        spomt1=1.11111e+60 spmb=1.11111e+15 spomb=0 spomb1=1.11111e+60
    M6 (CLKP CLKN VSS VSS) nch_ulvt_mac l=30n w=3u multi=1 nf=6 sd=100n \
        ad=1.5e-13 as=1.75e-13 pd=3.6u ps=4.7u nrd=0.175207 nrs=0.175207 \
        sa=239.369n sb=239.369n sa1=135.441n sa2=227.889n sa3=422.265n \
        sa4=228.196n sb1=135.441n sb2=227.889n sb3=422.265n spa=100n \
        spa1=100n spa2=100n spa3=100n sap=132.843n sapb=150.777n \
        spba=115.715n spba1=117.043n dfm_flag=0 spmt=1.11111e+15 spomt=0 \
        spomt1=1.11111e+60 spmb=1.11111e+15 spomb=0 spomb1=1.11111e+60
    M20 (VBSTP VDD CLKP VSS) nch_ulvt_mac l=30n w=2u multi=1 nf=4 sd=100n \
        ad=1e-13 as=1.25e-13 pd=2.4u ps=3.5u nrd=0.248269 nrs=0.248269 \
        sa=179.203n sb=179.203n sa1=118.069n sa2=174.76n sa3=310.76n \
        sa4=171.966n sb1=118.069n sb2=174.76n sb3=310.76n spa=100n \
        spa1=100n spa2=100n spa3=100n sap=120.952n sapb=140.537n \
        spba=115.715n spba1=117.043n dfm_flag=0 spmt=1.11111e+15 spomt=0 \
        spomt1=1.11111e+60 spmb=1.11111e+15 spomb=0 spomb1=1.11111e+60
    M19 (net38 VBSTN VINN VSS) nch_ulvt_mac l=30n w=2u multi=1 nf=4 \
        sd=100n ad=1e-13 as=1.25e-13 pd=2.4u ps=3.5u nrd=0.248269 \
        nrs=0.248269 sa=179.203n sb=179.203n sa1=118.069n sa2=174.76n \
        sa3=310.76n sa4=171.966n sb1=118.069n sb2=174.76n sb3=310.76n \
        spa=100n spa1=100n spa2=100n spa3=100n sap=120.952n sapb=140.537n \
        spba=115.715n spba1=117.043n dfm_flag=0 spmt=1.11111e+15 spomt=0 \
        spomt1=1.11111e+60 spmb=1.11111e+15 spomb=0 spomb1=1.11111e+60
    M18 (net41 VBSTN net38 VSS) nch_ulvt_mac l=30n w=250.0n multi=1 nf=1 \
        sd=100n ad=1.875e-14 as=1.875e-14 pd=650.0n ps=650.0n nrd=1.338763 \
        nrs=1.338763 sa=75.0n sb=75.0n sa1=75.0n sa2=75.0n sa3=75.0n \
        sa4=75.0n sb1=75.0n sb2=75.0n sb3=75.0n spa=100n spa1=100n \
        spa2=100n spa3=100n sap=91.9776n sapb=114.444n spba=115.715n \
        spba1=117.043n dfm_flag=0 spmt=1.11111e+15 spomt=0 \
        spomt1=1.11111e+60 spmb=1.11111e+15 spomb=0 spomb1=1.11111e+60
    M21 (VBSTN VDD CLKP VSS) nch_ulvt_mac l=30n w=2u multi=1 nf=4 sd=100n \
        ad=1e-13 as=1.25e-13 pd=2.4u ps=3.5u nrd=0.248269 nrs=0.248269 \
        sa=179.203n sb=179.203n sa1=118.069n sa2=174.76n sa3=310.76n \
        sa4=171.966n sb1=118.069n sb2=174.76n sb3=310.76n spa=100n \
        spa1=100n spa2=100n spa3=100n sap=120.952n sapb=140.537n \
        spba=115.715n spba1=117.043n dfm_flag=0 spmt=1.11111e+15 spomt=0 \
        spomt1=1.11111e+60 spmb=1.11111e+15 spomb=0 spomb1=1.11111e+60
    M12 (net40 CLKN VSS VSS) nch_ulvt_mac l=30n w=1u multi=1 nf=2 sd=100n \
        ad=5e-14 as=7.5e-14 pd=1.2u ps=2.3u nrd=0.425847 nrs=0.425847 \
        sa=112.742n sb=112.742n sa1=93.6047n sa2=112.078n sa3=163.715n \
        sa4=110.059n sb1=93.6047n sb2=112.078n sb3=163.715n spa=100n \
        spa1=100n spa2=100n spa3=100n sap=104.359n sapb=125.813n \
        spba=115.715n spba1=117.043n dfm_flag=0 spmt=1.11111e+15 spomt=0 \
        spomt1=1.11111e+60 spmb=1.11111e+15 spomb=0 spomb1=1.11111e+60
    M15 (net42 CLKP net40 VSS) nch_ulvt_mac l=30n w=250.0n multi=1 nf=1 \
        sd=100n ad=1.875e-14 as=1.875e-14 pd=650.0n ps=650.0n nrd=1.338763 \
        nrs=1.338763 sa=75.0n sb=75.0n sa1=75.0n sa2=75.0n sa3=75.0n \
        sa4=75.0n sb1=75.0n sb2=75.0n sb3=75.0n spa=100n spa1=100n \
        spa2=100n spa3=100n sap=91.9776n sapb=114.444n spba=115.715n \
        spba1=117.043n dfm_flag=0 spmt=1.11111e+15 spomt=0 \
        spomt1=1.11111e+60 spmb=1.11111e+15 spomb=0 spomb1=1.11111e+60
    M11 (net38 CLKN VSS VSS) nch_ulvt_mac l=30n w=1u multi=1 nf=2 sd=100n \
        ad=5e-14 as=7.5e-14 pd=1.2u ps=2.3u nrd=0.425847 nrs=0.425847 \
        sa=112.742n sb=112.742n sa1=93.6047n sa2=112.078n sa3=163.715n \
        sa4=110.059n sb1=93.6047n sb2=112.078n sb3=163.715n spa=100n \
        spa1=100n spa2=100n spa3=100n sap=104.359n sapb=125.813n \
        spba=115.715n spba1=117.043n dfm_flag=0 spmt=1.11111e+15 spomt=0 \
        spomt1=1.11111e+60 spmb=1.11111e+15 spomb=0 spomb1=1.11111e+60
    M13 (net41 CLKP net38 VSS) nch_ulvt_mac l=30n w=250.0n multi=1 nf=1 \
        sd=100n ad=1.875e-14 as=1.875e-14 pd=650.0n ps=650.0n nrd=1.338763 \
        nrs=1.338763 sa=75.0n sb=75.0n sa1=75.0n sa2=75.0n sa3=75.0n \
        sa4=75.0n sb1=75.0n sb2=75.0n sb3=75.0n spa=100n spa1=100n \
        spa2=100n spa3=100n sap=91.9776n sapb=114.444n spba=115.715n \
        spba1=117.043n dfm_flag=0 spmt=1.11111e+15 spomt=0 \
        spomt1=1.11111e+60 spmb=1.11111e+15 spomb=0 spomb1=1.11111e+60
    M0 (net40 VBSTP VINP VSS) nch_ulvt_mac l=30n w=2u multi=1 nf=4 sd=100n \
        ad=1e-13 as=1.25e-13 pd=2.4u ps=3.5u nrd=0.248269 nrs=0.248269 \
        sa=179.203n sb=179.203n sa1=118.069n sa2=174.76n sa3=310.76n \
        sa4=171.966n sb1=118.069n sb2=174.76n sb3=310.76n spa=100n \
        spa1=100n spa2=100n spa3=100n sap=120.952n sapb=140.537n \
        spba=115.715n spba1=117.043n dfm_flag=0 spmt=1.11111e+15 spomt=0 \
        spomt1=1.11111e+60 spmb=1.11111e+15 spomb=0 spomb1=1.11111e+60
    M8 (CLKP CLKN VDD VDD) pch_ulvt_mac l=30n w=3u multi=1 nf=6 sd=100n \
        ad=1.5e-13 as=1.75e-13 pd=3.6u ps=4.7u nrd=0.076399 nrs=0.076399 \
        sa=239.369n sb=239.369n sa1=135.441n sa2=227.889n sa3=422.265n \
        sa4=228.196n sb1=135.441n sb2=227.889n sb3=422.265n spa=100n \
        spa1=100n spa2=100n spa3=100n sap=132.843n sapb=150.777n \
        spba=115.715n spba1=117.043n dfm_flag=0 spmt=1.11111e+15 spomt=0 \
        spomt1=1.11111e+60 spmb=1.11111e+15 spomb=0 spomb1=1.11111e+60
    M17 (VBSTN net41 net37 net37) pch_ulvt_mac l=30n w=1.5u multi=1 nf=3 \
        sd=100n ad=8.75e-14 as=8.75e-14 pd=2.35u ps=2.35u nrd=0.147028 \
        nrs=0.147028 sa=147.042n sb=147.042n sa1=107.158n sa2=144.915n \
        sa3=241.797n sa4=141.98n sb1=107.158n sb2=144.915n sb3=241.797n \
        spa=100n spa1=100n spa2=100n spa3=100n sap=113.519n sapb=134.009n \
        spba=115.715n spba1=117.043n dfm_flag=0 spmt=1.11111e+15 spomt=0 \
        spomt1=1.11111e+60 spmb=1.11111e+15 spomb=0 spomb1=1.11111e+60
    M25 (VDD VBSTP net39 net39) pch_ulvt_mac l=30n w=500n multi=1 nf=1 \
        sd=100n ad=3.75e-14 as=3.75e-14 pd=1.15u ps=1.15u nrd=0.383209 \
        nrs=0.383209 sa=75.0n sb=75.0n sa1=75.0n sa2=75.0n sa3=75.0n \
        sa4=75.0n sb1=75.0n sb2=75.0n sb3=75.0n spa=100n spa1=100n \
        spa2=100n spa3=100n sap=91.9776n sapb=114.444n spba=115.715n \
        spba1=117.043n dfm_flag=0 spmt=1.11111e+15 spomt=0 \
        spomt1=1.11111e+60 spmb=1.11111e+15 spomb=0 spomb1=1.11111e+60
    M27 (VDD VBSTN net37 net37) pch_ulvt_mac l=30n w=500n multi=1 nf=1 \
        sd=100n ad=3.75e-14 as=3.75e-14 pd=1.15u ps=1.15u nrd=0.383209 \
        nrs=0.383209 sa=75.0n sb=75.0n sa1=75.0n sa2=75.0n sa3=75.0n \
        sa4=75.0n sb1=75.0n sb2=75.0n sb3=75.0n spa=100n spa1=100n \
        spa2=100n spa3=100n sap=91.9776n sapb=114.444n spba=115.715n \
        spba1=117.043n dfm_flag=0 spmt=1.11111e+15 spomt=0 \
        spomt1=1.11111e+60 spmb=1.11111e+15 spomb=0 spomb1=1.11111e+60
    M28 (net41 CLKP VDD VDD) pch_ulvt_mac l=30n w=250.0n multi=1 nf=1 \
        sd=100n ad=1.875e-14 as=1.875e-14 pd=650.0n ps=650.0n nrd=0.777777 \
        nrs=0.777777 sa=75.0n sb=75.0n sa1=75.0n sa2=75.0n sa3=75.0n \
        sa4=75.0n sb1=75.0n sb2=75.0n sb3=75.0n spa=100n spa1=100n \
        spa2=100n spa3=100n sap=91.9776n sapb=114.444n spba=115.715n \
        spba1=117.043n dfm_flag=0 spmt=1.11111e+15 spomt=0 \
        spomt1=1.11111e+60 spmb=1.11111e+15 spomb=0 spomb1=1.11111e+60
    M7 (VBSTP net42 net39 net39) pch_ulvt_mac l=30n w=1.5u multi=1 nf=3 \
        sd=100n ad=8.75e-14 as=8.75e-14 pd=2.35u ps=2.35u nrd=0.147028 \
        nrs=0.147028 sa=147.042n sb=147.042n sa1=107.158n sa2=144.915n \
        sa3=241.797n sa4=141.98n sb1=107.158n sb2=144.915n sb3=241.797n \
        spa=100n spa1=100n spa2=100n spa3=100n sap=113.519n sapb=134.009n \
        spba=115.715n spba1=117.043n dfm_flag=0 spmt=1.11111e+15 spomt=0 \
        spomt1=1.11111e+60 spmb=1.11111e+15 spomb=0 spomb1=1.11111e+60
    M26 (net42 CLKP VDD VDD) pch_ulvt_mac l=30n w=250.0n multi=1 nf=1 \
        sd=100n ad=1.875e-14 as=1.875e-14 pd=650.0n ps=650.0n nrd=0.777777 \
        nrs=0.777777 sa=75.0n sb=75.0n sa1=75.0n sa2=75.0n sa3=75.0n \
        sa4=75.0n sb1=75.0n sb2=75.0n sb3=75.0n spa=100n spa1=100n \
        spa2=100n spa3=100n sap=91.9776n sapb=114.444n spba=115.715n \
        spba1=117.043n dfm_flag=0 spmt=1.11111e+15 spomt=0 \
        spomt1=1.11111e+60 spmb=1.11111e+15 spomb=0 spomb1=1.11111e+60
// @RNL(author="rnl-virtuoso") {
//   %block_symbol = @DEFINE-SYMBOL(box=[-10, -8, 10, 8]) {
//     @LINE {(12, 1) (8, 1)};
//     @LINE {(-12, -1) (-8, -1)};
//     @LINE {(-2, 1.5) (-1, 1.5)};
//     @LINE {(-1, -10) (-1, -6)};
//     @LINE {(-3, 0) (-0.5, 0)};
//     @LINE {(-0.5, 1) (-0.5, -1)};
//     @LINE {(0.5, 1) (0.5, -1)};
//     @LINE {(1, -10) (1, -6)};
//     @LINE {(0, 10) (0, 6)};
//     @LINE {(-12, 1) (-8, 1)};
//     @LINE {(1, 1.5) (1.5, 1.5)};
//     @LINE {(1.5, 2) (1.5, 1)};
//     @LINE {(2, 1.5) (1.5, 1.5)};
//     @LINE {(0.5, 0) (3, 0)};
//     @LINE {(-8, 6) (8, 6) (8, -6) (-8, -6) (-8, 6)};
//     @LINE {(12, -1) (8, -1)};
//     ? @TEXT("${model}", size=1, halign="start", valign="middle", key="model") => @PLACE(6, 5);
//     ? @TEXT("${name}", size=1, halign="start", valign="middle", key="name") => @PLACE(6, 7);
//     (12, -1) @PIN(terminal="VBSTN");
//     (7.4, -1) @TEXT("VBSTN", size=1, halign="end", valign="middle");
//     (0, 10) @PIN(terminal="CLKN");
//     (0, 5.9) @TEXT("CLKN", size=1, halign="end", valign="middle", rotate=90);
//     (1, -10) @PIN(terminal="VSS");
//     (1, -5.4) @TEXT("VSS", size=1, halign="start", valign="middle", rotate=90);
//     (-1, -10) @PIN(terminal="VDD");
//     (-1, -5.4) @TEXT("VDD", size=1, halign="start", valign="middle", rotate=90);
//     (-12, 1) @PIN(terminal="VINP");
//     (-7.4, 1) @TEXT("VINP", size=1, halign="start", valign="middle");
//     (12, 1) @PIN(terminal="VBSTP");
//     (7.4, 1) @TEXT("VBSTP", size=1, halign="end", valign="middle");
//     (-12, -1) @PIN(terminal="VINN");
//     (-7.4, -1) @TEXT("VINN", size=1, halign="start", valign="middle")
//   };
//   # @SET-SYMBOL %block_symbol;
//   %symbol_0 = @DEFINE-SYMBOL(box=[-0.1, -2.8, 3.8, 2.8]) {
//     @LINE {(2, 1.5) (4, 1.5) (4, 3)};
//     @LINE {(2, -1.5) (2, 1.5)};
//     @LINE {(3, -1) (4, -1.5) (3, -2)};
//     @LINE {(0, 0) (1.5, 0)};
//     @LINE {(1.5, 1.5) (1.5, -1.5)};
//     @LINE {(2, -1.5) (4, -1.5) (4, -3)};
//     ? @TEXT("${name}", size=0.8, halign="start", valign="baseline", key="name") => @PLACE(5, 3.5);
//     ? @TEXT("${model}", size=0.8, halign="end", valign="baseline", key="model") => @PLACE(3.2, 3.2);
//     (4, -1) @PIN(terminal=4);
//     (4, -3) @PIN(terminal=3);
//     (4, 3) @PIN(terminal=1);
//     (0, 0) @PIN(terminal=2)
//   };
//   #"M1" @SET-SYMBOL %symbol_0;
//   #"M1" @PLACE(5, -16) => @ORIENT("MY");
//   #"M21" @SET-SYMBOL %symbol_0;
//   #"M21" @PLACE(33, 20) => @ORIENT("R270");
//   %symbol_1 = @DEFINE-SYMBOL(box=[-2, -6, 2, 0]) {
//     @LINE {(1, -2.2) (-1, -2.2)};
//     @LINE {(0, 0) (0, -2.2)};
//     @LINE {(0, -2.8) (0, -6)};
//     @ARC {(1, -3.2) (0, -2.8) (-1, -3.2)};
//     ? @TEXT("${name}", size=0.8, halign="start", valign="baseline", key="name") => @PLACE(1.4, 0.1);
//     ? @TEXT("${model}", size=0.8, halign="end", valign="baseline", key="model") => @PLACE(-1.1, 0.3);
//     (0, 0) @PIN(terminal=1);
//     (0, -6) @PIN(terminal=2)
//   };
//   #"C1" @SET-SYMBOL %symbol_1;
//   #"C1" @PLACE(57, 3) => @ORIENT("MY");
//   #"C0" @SET-SYMBOL %symbol_1;
//   #"C0" @PLACE(-7, 3) => @ORIENT("R0");
//   #"C3" @SET-SYMBOL %symbol_1;
//   #"C3" @PLACE(53, 3) => @ORIENT("R0");
//   %symbol_2 = @DEFINE-SYMBOL(box=[-0.1, -2.8, 3.8, 2.8]) {
//     @LINE {(0, 0) (0.7, 0)};
//     @LINE {(1.5, 1.5) (1.5, -1.5)};
//     @LINE {(2, -1.5) (4, -1.5) (4, -3)};
//     @LINE {(2, 1.5) (4, 1.5) (4, 3)};
//     (1.1, 0) @CIRCLE(radius=0.4);
//     @LINE {(3.7, 2) (2.7, 1.5) (3.7, 1)};
//     @LINE {(2, -1.5) (2, 1.5)};
//     ? @TEXT("${name}", size=0.8, halign="start", valign="baseline", key="name") => @PLACE(4.9, 3.4);
//     ? @TEXT("${model}", size=0.8, halign="end", valign="baseline", key="model") => @PLACE(3.3, 3.2);
//     (4, 3) @PIN(terminal=3);
//     (4, 1) @PIN(terminal=4);
//     (0, 0) @PIN(terminal=2);
//     (4, -3) @PIN(terminal=1)
//   };
//   #"M25" @SET-SYMBOL %symbol_2;
//   #"M25" @PLACE(-3, 16) => @ORIENT("R180");
//   #"M0" @SET-SYMBOL %symbol_0;
//   #"M0" @PLACE(9, -20) => @ORIENT("MYR90");
//   #"M28" @SET-SYMBOL %symbol_2;
//   #"M28" @PLACE(69, 0) => @ORIENT("MY");
//   #"M13" @SET-SYMBOL %symbol_0;
//   #"M13" @PLACE(69, -16) => @ORIENT("MY");
//   #"M19" @SET-SYMBOL %symbol_0;
//   #"M19" @PLACE(41, -20) => @ORIENT("R270");
//   #"M18" @SET-SYMBOL %symbol_0;
//   #"M18" @PLACE(45, -16) => @ORIENT("R0");
//   #"M26" @SET-SYMBOL %symbol_2;
//   #"M26" @PLACE(-19, 0) => @ORIENT("R0");
//   #"M7" @SET-SYMBOL %symbol_2;
//   #"M7" @PLACE(1, 4) => @ORIENT("R90");
//   #"M17" @SET-SYMBOL %symbol_2;
//   #"M17" @PLACE(49, 4) => @ORIENT("MXR90");
//   #"M11" @SET-SYMBOL %symbol_0;
//   #"M11" @PLACE(69, -32) => @ORIENT("MY");
//   #"M8" @SET-SYMBOL %symbol_2;
//   #"M8" @PLACE(17, 34) => @ORIENT("MYR90");
//   #"M12" @SET-SYMBOL %symbol_0;
//   #"M12" @PLACE(-19, -32) => @ORIENT("R0");
//   #"M6" @SET-SYMBOL %symbol_0;
//   #"M6" @PLACE(33, 34) => @ORIENT("MYR90");
//   #"C2" @SET-SYMBOL %symbol_1;
//   #"C2" @PLACE(-3, 3) => @ORIENT("R0");
//   #"M15" @SET-SYMBOL %symbol_0;
//   #"M15" @PLACE(-19, -16) => @ORIENT("R0");
//   #"M20" @SET-SYMBOL %symbol_0;
//   #"M20" @PLACE(17, 20) => @ORIENT("MYR90");
//   #"M27" @SET-SYMBOL %symbol_2;
//   #"M27" @PLACE(53, 16) => @ORIENT("MX");
//   %port_0 = $IO_PORT @ATTACH &"VSS" => @PLACE(-30, 26) => @ORIENT("R0");
//   %port_1 = $IO_PORT @ATTACH &"VDD" => @PLACE(-30, 30) => @ORIENT("R0");
//   %input_port_symbol = @DEFINE-SYMBOL(box=[-2, -1, 0, 1]) {
//       @LINE(fill="linecolor", linestyle="none") {(-2, -0.9) (-2, 0.9) (-0.9, 0.9) (0, 0) (-0.9, -0.9) (-2, -0.9)};
//       (0, 0) @PIN(terminal=1, direction="right");
//       ? @TEXT("${name}", key="name", halign="middle") => @PLACE(-1, 1.6)
//     };
//   %port_2 = $IO_PORT @ATTACH &"VINP" => @PLACE(18, -24) => @ORIENT("R180");
//   %port_2 @SET-SYMBOL %input_port_symbol;
//   %port_2 @TEXT("VINP", key="name");
//   %port_3 = $IO_PORT @ATTACH &"CLKN" => @PLACE(25, 42) => @ORIENT("R270");
//   %port_3 @SET-SYMBOL %input_port_symbol;
//   %port_3 @TEXT("CLKN", key="name");
//   %port_4 = $IO_PORT @ATTACH &"CLKN" => @PLACE(-23, -32) => @ORIENT("R0");
//   %port_4 @SET-SYMBOL %input_port_symbol;
//   %port_4 @TEXT("CLKN", key="name");
//   %port_5 = $IO_PORT @ATTACH &"CLKN" => @PLACE(73, -32) => @ORIENT("MY");
//   %port_5 @SET-SYMBOL %input_port_symbol;
//   %port_5 @TEXT("CLKN", key="name");
//   %port_6 = $IO_PORT @ATTACH &"VINN" => @PLACE(32, -24) => @ORIENT("MX");
//   %port_6 @SET-SYMBOL %input_port_symbol;
//   %port_6 @TEXT("VINN", key="name");
//   %output_port_symbol = @DEFINE-SYMBOL(box=[0, -1, 2, 1]) {
//       @LINE(fill="linecolor", linestyle="none") {(0, -0.9) (0, 0.9) (1.1, 0.9) (2, 0) (1.1, -0.9) (0, -0.9)};
//       (0, 0) @PIN(terminal=1, direction="left");
//       ? @TEXT("${name}", key="name", halign="middle") => @PLACE(1, 1.6)
//     };
//   %port_7 = $IO_PORT @ATTACH &"VBSTP" => @PLACE(18, -8) => @ORIENT("R0");
//   %port_7 @SET-SYMBOL %output_port_symbol;
//   %port_7 @TEXT("VBSTP", key="name");
//   %port_8 = $IO_PORT @ATTACH &"VBSTN" => @PLACE(32, -8) => @ORIENT("MY");
//   %port_8 @SET-SYMBOL %output_port_symbol;
//   %port_8 @TEXT("VBSTN", key="name");
//   %p0 = (-15, -8);
//   %wire_0 = &"net42" @WIRE(mode="straight") {%p0 #"M26":1};
//   %wire_1 = &"net42" @WIRE(mode="straight") {#"M15":1 %p0};
//   %p1 = (1, -8);
//   %wire_2 = &"net42" @WIRE(mode="straight") {#"M1":1 %p1};
//   %wire_3 = &"net42" @WIRE(mode="straight") {%p1 #"M7":2};
//   %wire_4 = &"net42" @WIRE(mode="straight") {%p0 %p1};
//   %p2 = (65, -8);
//   %wire_5 = &"net41" @WIRE(mode="straight") {%p2 #"M28":1};
//   %wire_6 = &"net41" @WIRE(mode="straight") {#"M13":1 %p2};
//   %p3 = (49, -8);
//   %wire_7 = &"net41" @WIRE(mode="straight") {%p2 %p3};
//   %wire_8 = &"net41" @WIRE(mode="straight") {%p3 #"M17":2};
//   %wire_9 = &"net41" @WIRE(mode="straight") {#"M18":1 %p3};
//   %wire_10 = &"net40" @WIRE(mode="straight") {#"C0":2 #"C2":2};
//   %p4 = (-7, -24);
//   %p5 = (1, -24);
//   %wire_11 = &"net40" @WIRE(mode="straight") {%p4 %p5};
//   %wire_12 = &"net40" @WIRE(mode="straight") {%p4 #"C0":2};
//   %p6 = (-15, -24);
//   %wire_13 = &"net40" @WIRE(mode="straight") {#"M12":1 %p6};
//   %wire_14 = &"net40" @WIRE(mode="straight") {%p6 %p4};
//   %wire_15 = &"net40" @WIRE(mode="straight") {%p6 #"M15":3};
//   %wire_16 = &"net40" @WIRE(mode="straight") {%p5 #"M0":1};
//   %wire_17 = &"net40" @WIRE(mode="straight") {%p5 #"M1":3};
//   %wire_18 = &"net39" @WIRE(mode="straight") {#"C0":1 #"C2":1};
//   %p7 = (-8, 15);
//   %wire_19 = &"net39" @WIRE(mode="straight") {%p7 #"M25":4};
//   %p8 = (-7, 8);
//   %wire_20 = &"net39" @WIRE(mode="straight") {#"C0":1 %p8};
//   %p9 = (-8, 13);
//   %wire_21 = &"net39" @WIRE(mode="straight") {%p9 %p7};
//   %wire_22 = &"net39" @WIRE(mode="straight") {%p9 #"M25":3};
//   %wire_23 = &"net39" @WIRE(mode="straight") {%p8 #"M25":3};
//   %wire_24 = &"net39" @WIRE(mode="straight") {%p8 #"M7":3};
//   %p10 = (0, 9);
//   %wire_25 = &"net39" @WIRE(mode="straight") {#"M7":4 %p10};
//   %p11 = (-2, 9);
//   %wire_26 = &"net39" @WIRE(mode="straight") {%p11 %p10};
//   %wire_27 = &"net39" @WIRE(mode="straight") {#"M7":3 %p11};
//   %wire_28 = &"net38" @WIRE(mode="straight") {#"C3":2 #"C1":2};
//   %p12 = (57, -24);
//   %wire_29 = &"net38" @WIRE(mode="straight") {%p12 #"C1":2};
//   %p13 = (65, -24);
//   %wire_30 = &"net38" @WIRE(mode="straight") {%p13 %p12};
//   %wire_31 = &"net38" @WIRE(mode="straight") {%p13 #"M13":3};
//   %wire_32 = &"net38" @WIRE(mode="straight") {#"M11":1 %p13};
//   %p14 = (49, -24);
//   %wire_33 = &"net38" @WIRE(mode="straight") {%p12 %p14};
//   %wire_34 = &"net38" @WIRE(mode="straight") {%p14 #"M18":3};
//   %wire_35 = &"net38" @WIRE(mode="straight") {%p14 #"M19":1};
//   %wire_36 = &"net37" @WIRE(mode="straight") {#"C3":1 #"C1":1};
//   %p15 = (50, 9);
//   %wire_37 = &"net37" @WIRE(mode="straight") {#"M17":4 %p15};
//   %p16 = (52, 9);
//   %wire_38 = &"net37" @WIRE(mode="straight") {%p16 %p15};
//   %wire_39 = &"net37" @WIRE(mode="straight") {#"M17":3 %p16};
//   %p17 = (57, 8);
//   %wire_40 = &"net37" @WIRE(mode="straight") {%p17 #"M17":3};
//   %wire_41 = &"net37" @WIRE(mode="straight") {#"C1":1 %p17};
//   %wire_42 = &"net37" @WIRE(mode="straight") {%p17 #"M27":3};
//   %p18 = (58, 15);
//   %wire_43 = &"net37" @WIRE(mode="straight") {%p18 #"M27":4};
//   %p19 = (58, 13);
//   %wire_44 = &"net37" @WIRE(mode="straight") {%p19 #"M27":3};
//   %wire_45 = &"net37" @WIRE(mode="straight") {%p19 %p18};
//   %p20 = (79, -8);
//   %p21 = (73, -8);
//   %wire_46 = &"CLKP" @WIRE(mode="straight") {%p20 %p21};
//   %p22 = (73, -16);
//   %wire_47 = &"CLKP" @WIRE(mode="straight") {%p22 #"M13":2};
//   %p23 = (25, 30);
//   %wire_48 = &"CLKP" @WIRE(mode="straight") {#"M8":1 %p23};
//   %p24 = (-29, -8);
//   %p25 = (-23, -8);
//   %wire_49 = &"CLKP" @WIRE(mode="straight") {%p24 %p25};
//   %wire_50 = &"CLKP" @WIRE(mode="straight") {%p22 %p21};
//   %p26 = (25, 16);
//   %wire_51 = &"CLKP" @WIRE(mode="straight") {%p26 %p23};
//   %p27 = (73, 0);
//   %wire_52 = &"CLKP" @WIRE(mode="straight") {%p27 #"M28":2};
//   %wire_53 = &"CLKP" @WIRE(mode="straight") {%p21 %p27};
//   %p28 = (-23, -16);
//   %wire_54 = &"CLKP" @WIRE(mode="straight") {%p28 #"M15":2};
//   %p29 = (-23, 0);
//   %wire_55 = &"CLKP" @WIRE(mode="straight") {%p29 #"M26":2};
//   %wire_56 = &"CLKP" @WIRE(mode="straight") {%p28 %p25};
//   %wire_57 = &"CLKP" @WIRE(mode="straight") {%p25 %p29};
//   %wire_58 = &"CLKP" @WIRE(mode="straight") {#"M20":3 %p26};
//   %wire_59 = &"CLKP" @WIRE(mode="straight") {%p26 #"M21":3};
//   %wire_60 = &"CLKP" @WIRE(mode="straight") {%p23 #"M6":1};
//   %wire_49 @TEXT("CLKP", size=1, halign="middle", valign="baseline") => @PLACE(-27, -7.3);
//   %wire_48 @TEXT("CLKP", size=1, halign="middle", valign="baseline") => @PLACE(25, 30.7);
//   %wire_46 @TEXT("CLKP", size=1, halign="middle", valign="baseline") => @PLACE(77, -7.3);
//   %p30 = (41, 16);
//   %wire_61 = &"VBSTN" @WIRE(mode="straight") {#"M27":2 %p30};
//   %p31 = (41, 8);
//   %wire_62 = &"VBSTN" @WIRE(mode="straight") {#"M17":1 %p31};
//   %p32 = (41, -16);
//   %wire_63 = &"VBSTN" @WIRE(mode="straight") {#"M18":2 %p32};
//   %p33 = (41, -8);
//   %wire_64 = &"VBSTN" @WIRE(mode="straight") {%p33 %p31};
//   %wire_65 = &"VBSTN" @WIRE(mode="straight") {%p31 %p30};
//   %wire_66 = &"VBSTN" @WIRE(mode="straight") {%p32 %p33};
//   %wire_67 = &"VBSTN" @WIRE(mode="straight") {#"M19":2 %p32};
//   %wire_68 = &"VBSTN" @WIRE(mode="straight") {%p30 #"M21":1};
//   %wire_69 = &"VBSTN" @WIRE(mode="straight") {%p33 %port_8:p};
//   %p34 = (9, -8);
//   %wire_70 = &"VBSTP" @WIRE(mode="straight") {%p34 %port_7:p};
//   %p35 = (9, 16);
//   %wire_71 = &"VBSTP" @WIRE(mode="straight") {#"M25":2 %p35};
//   %p36 = (9, 8);
//   %wire_72 = &"VBSTP" @WIRE(mode="straight") {%p36 %p35};
//   %wire_73 = &"VBSTP" @WIRE(mode="straight") {#"M7":1 %p36};
//   %wire_74 = &"VBSTP" @WIRE(mode="straight") {%p34 %p36};
//   %p37 = (9, -16);
//   %wire_75 = &"VBSTP" @WIRE(mode="straight") {#"M1":2 %p37};
//   %wire_76 = &"VBSTP" @WIRE(mode="straight") {#"M0":2 %p37};
//   %wire_77 = &"VBSTP" @WIRE(mode="straight") {%p35 #"M20":1};
//   %wire_78 = &"VBSTP" @WIRE(mode="straight") {%p37 %p34};
//   %wire_79 = &"VINN" @WIRE(mode="straight") {#"M19":3 %port_6:p};
//   %wire_80 = &"CLKN" @WIRE(mode="straight") {%port_5:p #"M11":2};
//   %p38 = (33, 36);
//   %wire_81 = &"CLKN" @WIRE(mode="straight") {#"M6":2 %p38};
//   %p39 = (17, 36);
//   %p40 = (25, 36);
//   %wire_82 = &"CLKN" @WIRE(mode="straight") {%p39 %p40};
//   %wire_83 = &"CLKN" @WIRE(mode="straight") {#"M8":2 %p39};
//   %wire_84 = &"CLKN" @WIRE(mode="straight") {%p40 %p38};
//   %wire_85 = &"CLKN" @WIRE(mode="straight") {%port_4:p #"M12":2};
//   %wire_86 = &"CLKN" @WIRE(mode="straight") {%p40 %port_3:p};
//   %wire_87 = &"VINP" @WIRE(mode="straight") {#"M0":3 %port_2:p};
//   %p41 = (57, 24);
//   %wire_88 = &"VDD" @WIRE(mode="straight") {#"M27":1 %p41};
//   %p42 = (65, 8);
//   %wire_89 = &"VDD" @WIRE(mode="straight") {#"M28":3 %p42};
//   %p43 = (64, 1);
//   %wire_90 = &"VDD" @WIRE(mode="straight") {#"M28":4 %p43};
//   %p44 = (-15, 8);
//   %wire_91 = &"VDD" @WIRE(mode="straight") {#"M26":3 %p44};
//   %p45 = (-7, 24);
//   %wire_92 = &"VDD" @WIRE(mode="straight") {#"M25":1 %p45};
//   %p46 = (14, 29);
//   %wire_93 = &"VDD" @WIRE(mode="straight") {%p46 #"M8":3};
//   %p47 = (64, 3);
//   %wire_94 = &"VDD" @WIRE(mode="straight") {%p43 %p47};
//   %wire_95 = &"VDD" @WIRE(mode="straight") {#"M28":3 %p47};
//   %p48 = (16, 29);
//   %wire_96 = &"VDD" @WIRE(mode="straight") {%p48 %p46};
//   %wire_97 = &"VDD" @WIRE(mode="straight") {%p48 #"M8":4};
//   %p49 = (9, 30);
//   %wire_98 = &"VDD" @WIRE(mode="straight") {#"M8":3 %p49};
//   %p50 = (17, 24);
//   %wire_99 = &"VDD" @WIRE(mode="straight") {#"M20":2 %p50};
//   %p51 = (-14, 1);
//   %wire_100 = &"VDD" @WIRE(mode="straight") {#"M26":4 %p51};
//   %p52 = (-14, 3);
//   %wire_101 = &"VDD" @WIRE(mode="straight") {%p51 %p52};
//   %wire_102 = &"VDD" @WIRE(mode="straight") {#"M26":3 %p52};
//   %p53 = (33, 24);
//   %wire_103 = &"VDD" @WIRE(mode="straight") {#"M21":2 %p53};
//   %wire_103 @TEXT("VDD", size=1, halign="middle", valign="top", rotate=90) => @PLACE(33.7, 22);
//   %wire_99 @TEXT("VDD", size=1, halign="middle", valign="baseline", rotate=90) => @PLACE(16.3, 22);
//   %wire_98 @TEXT("VDD", size=1, halign="middle", valign="top") => @PLACE(11, 29.3);
//   %wire_92 @TEXT("VDD", size=1, halign="middle", valign="baseline", rotate=90) => @PLACE(-7.7, 22);
//   %wire_91 @TEXT("VDD", size=1, halign="middle", valign="baseline", rotate=90) => @PLACE(-15.7, 6);
//   %wire_89 @TEXT("VDD", size=1, halign="middle", valign="top", rotate=90) => @PLACE(65.7, 6);
//   %wire_88 @TEXT("VDD", size=1, halign="middle", valign="top", rotate=90) => @PLACE(57.7, 22);
//   %p54 = (64, -33);
//   %wire_104 = &"VSS" @WIRE(mode="straight") {#"M11":4 %p54};
//   %p55 = (61, -17);
//   %wire_105 = &"VSS" @WIRE(mode="straight") {#"M13":4 %p55};
//   %p56 = (64, -35);
//   %wire_106 = &"VSS" @WIRE(mode="straight") {#"M11":3 %p56};
//   %p57 = (-15, -40);
//   %wire_107 = &"VSS" @WIRE(mode="straight") {%p57 #"M12":3};
//   %p58 = (36, 29);
//   %wire_108 = &"VSS" @WIRE(mode="straight") {%p58 #"M6":3};
//   %p59 = (65, -40);
//   %wire_109 = &"VSS" @WIRE(mode="straight") {%p59 #"M11":3};
//   %p60 = (18, 12);
//   %wire_110 = &"VSS" @WIRE(mode="straight") {%p60 #"M20":4};
//   %wire_111 = &"VSS" @WIRE(mode="straight") {%p56 %p54};
//   %p61 = (41, 30);
//   %wire_112 = &"VSS" @WIRE(mode="straight") {#"M6":3 %p61};
//   %p62 = (-11, -17);
//   %wire_113 = &"VSS" @WIRE(mode="straight") {#"M15":4 %p62};
//   %p63 = (-3, -17);
//   %wire_114 = &"VSS" @WIRE(mode="straight") {%p63 #"M1":4};
//   %p64 = (10, -28);
//   %wire_115 = &"VSS" @WIRE(mode="straight") {%p64 #"M0":4};
//   %p65 = (-14, -35);
//   %wire_116 = &"VSS" @WIRE(mode="straight") {#"M12":3 %p65};
//   %p66 = (-14, -33);
//   %wire_117 = &"VSS" @WIRE(mode="straight") {%p65 %p66};
//   %wire_118 = &"VSS" @WIRE(mode="straight") {#"M12":4 %p66};
//   %p67 = (34, 29);
//   %wire_119 = &"VSS" @WIRE(mode="straight") {%p67 #"M6":4};
//   %wire_120 = &"VSS" @WIRE(mode="straight") {%p67 %p58};
//   %p68 = (53, -17);
//   %wire_121 = &"VSS" @WIRE(mode="straight") {%p68 #"M18":4};
//   %p69 = (40, -28);
//   %wire_122 = &"VSS" @WIRE(mode="straight") {%p69 #"M19":4};
//   %p70 = (32, 12);
//   %wire_123 = &"VSS" @WIRE(mode="straight") {%p70 #"M21":4};
//   %wire_123 @TEXT("VSS", size=1, halign="middle", valign="baseline", rotate=90) => @PLACE(31.3, 13);
//   %wire_122 @TEXT("VSS", size=1, halign="middle", valign="top", rotate=90) => @PLACE(40.7, -26);
//   %wire_121 @TEXT("VSS", size=1, halign="middle", valign="baseline") => @PLACE(51, -16.3);
//   %wire_115 @TEXT("VSS", size=1, halign="middle", valign="baseline", rotate=90) => @PLACE(9.3, -26);
//   %wire_114 @TEXT("VSS", size=1, halign="middle", valign="baseline") => @PLACE(-1, -16.3);
//   %wire_113 @TEXT("VSS", size=1, halign="middle", valign="baseline") => @PLACE(-13, -16.3);
//   %wire_112 @TEXT("VSS", size=1, halign="middle", valign="baseline") => @PLACE(39, 30.7);
//   %wire_110 @TEXT("VSS", size=1, halign="middle", valign="baseline", rotate=90) => @PLACE(17.3, 13);
//   %wire_109 @TEXT("VSS", size=1, halign="middle", valign="top", rotate=90) => @PLACE(65.7, -38);
//   %wire_107 @TEXT("VSS", size=1, halign="middle", valign="baseline", rotate=90) => @PLACE(-15.7, -38);
//   %wire_105 @TEXT("VSS", size=1, halign="middle", valign="baseline") => @PLACE(63, -16.3);
//   $JUNCTION @ATTACH %p0;
//   $JUNCTION @ATTACH %p1;
//   $JUNCTION @ATTACH %p2;
//   $JUNCTION @ATTACH %p3;
//   $JUNCTION @ATTACH %p4;
//   $JUNCTION @ATTACH %p5;
//   $JUNCTION @ATTACH %p6;
//   $JUNCTION @ATTACH %p8;
//   $JUNCTION @ATTACH %p12;
//   $JUNCTION @ATTACH %p13;
//   $JUNCTION @ATTACH %p14;
//   $JUNCTION @ATTACH %p17;
//   $JUNCTION @ATTACH %p21;
//   $JUNCTION @ATTACH %p23;
//   $JUNCTION @ATTACH %p25;
//   $JUNCTION @ATTACH %p26;
//   $JUNCTION @ATTACH %p30;
//   $JUNCTION @ATTACH %p31;
//   $JUNCTION @ATTACH %p32;
//   $JUNCTION @ATTACH %p33;
//   $JUNCTION @ATTACH %p34;
//   $JUNCTION @ATTACH %p35;
//   $JUNCTION @ATTACH %p36;
//   $JUNCTION @ATTACH %p37;
//   $JUNCTION @ATTACH %p40
// }
ends L4_stage1_flash_bootstrapper
