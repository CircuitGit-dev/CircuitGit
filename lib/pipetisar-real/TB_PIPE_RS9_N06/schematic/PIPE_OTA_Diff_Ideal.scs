// RNL cell 2026_PIPETISAR_RESEARCH/PIPE_OTA_Diff_Ideal
// @RNL(type="header") {
//   @VERSION("0.3");
//   @USE-PACKAGE(name="rnl-std-spectre", version="0.3", path="rnl-std-spectre.rnl");
//   @USE-PACKAGE(name="eda-symbol", version="0.1", path="eda-symbol.rnl");
//   @USE-PACKAGE(name="eda-style", version="0.1", path="eda-style.rnl")
// }
subckt PIPE_OTA_Diff_Ideal Vcmo Vdd Vin Vinb Vout Voutb
parameters gm=1 gm_id=20 Gain=1e8
    I0 (Vdd 0) isource dc=gm/gm_id type=dc
    E4 (Vinb net023 0 0) vcvs gain=0
    R0 (Voutb Vcmo_int) resistor r=Gain/gm isnoisy=no
    R4 (Vcmo_int Vout) resistor r=Gain/gm isnoisy=no
    G0 (Voutb Vout Vin net023) vccs gm=gm/2
    G1 (Voutb 0 Vcmo_int Vcmo) vccs gm=20*gm
    G3 (Vout 0 Vcmo_int Vcmo) vccs gm=20*gm
// @RNL(author="rnl-virtuoso") {
//   %block_symbol = @DEFINE-SYMBOL(box=[10, -5, 30, 7]) {
//     @LINE {(20, 7) (20, 5)};
//     (13, -1) @CIRCLE(radius=1);
//     @LINE {(30, -1) (26, -1)};
//     (27, 3) @CIRCLE(radius=1);
//     @LINE {(10, 3) (14, 3)};
//     @LINE {(30, 1) (26, 1)};
//     @LINE {(28, 3) (30, 3)};
//     @LINE {(10, -1) (12, -1)};
//     @LINE {(14, 7) (14, -5) (26, 1) (14, 7)};
//     ? @TEXT("${model}", size=1, halign="middle", valign="middle", key="model") => @PLACE(18, 1);
//     ? @TEXT("${name}", size=1, halign="start", valign="middle", key="name") => @PLACE(14, 8);
//     (10, 3) @PIN(terminal="Vin");
//     (14.6, 3) @TEXT("Vin", size=1, halign="start", valign="middle");
//     (20, 7) @PIN(terminal="Vdd");
//     (19, 6.4) @TEXT("Vdd", size=1, halign="end", valign="middle", rotate=90);
//     (30, 3) @PIN(terminal="Voutb");
//     (25.4, 3) @TEXT("Voutb", size=1, halign="end", valign="middle");
//     (30, 1) @PIN(terminal="Vcmo");
//     (25.4, 1) @TEXT("Vcmo", size=1, halign="end", valign="middle");
//     (10, -1) @PIN(terminal="Vinb");
//     (14.6, -1) @TEXT("Vinb", size=1, halign="start", valign="middle");
//     (30, -1) @PIN(terminal="Vout");
//     (25.4, -1) @TEXT("Vout", size=1, halign="end", valign="middle")
//   };
//   # @SET-SYMBOL %block_symbol;
//   #"G0" @SET-SYMBOL $VCCS_4TERM;
//   #"G0" @PLACE(2, -2) => @ORIENT("R0");
//   #"G1" @SET-SYMBOL $VCCS_4TERM;
//   #"G1" @PLACE(46, 3) => @ORIENT("R0");
//   #"R4" @SET-SYMBOL $RESISTOR;
//   #"R4" @PLACE(25, -7) => @ORIENT("R0");
//   #"I0" @SET-SYMBOL $CURRENT_SOURCE;
//   #"I0" @PLACE(4, 26) => @ORIENT("R0");
//   #"G3" @SET-SYMBOL $VCCS_4TERM;
//   #"G3" @PLACE(46, -21) => @ORIENT("R0");
//   #"E4" @SET-SYMBOL $VCVS_4TERM;
//   #"E4" @PLACE(-9, -10) => @ORIENT("R90");
//   #"R0" @SET-SYMBOL $RESISTOR;
//   #"R0" @PLACE(25, 3) => @ORIENT("R0");
//   %marker_1 = $GROUND @ATTACH &"0" => @PLACE(47, -24) => @ORIENT("R0");
//   %marker_2 = $GROUND @ATTACH &"0" => @PLACE(-21, -15) => @ORIENT("R0");
//   %marker_6 = $GROUND @ATTACH &"0" => @PLACE(-13, -19) => @ORIENT("R0");
//   %marker_7 = $GROUND @ATTACH &"0" => @PLACE(-21, -1) => @ORIENT("R0");
//   %marker_8 = $GROUND @ATTACH &"0" => @PLACE(-5, -19) => @ORIENT("R0");
//   %marker_9 = $GROUND @ATTACH &"0" => @PLACE(47, 0) => @ORIENT("R0");
//   %marker_16 = $GROUND @ATTACH &"0" => @PLACE(4, 23) => @ORIENT("R0");
//   %port_0 = $IO_PORT @ATTACH &"Vdd" => @PLACE(2, 32) => @ORIENT("R0");
//   %input_port_symbol = @DEFINE-SYMBOL(box=[-2, -1, 0, 1]) {
//       @LINE(fill="linecolor", linestyle="none") {(-2, -0.9) (-2, 0.9) (-0.9, 0.9) (0, 0) (-0.9, -0.9) (-2, -0.9)};
//       (0, 0) @PIN(terminal=1, direction="right");
//       ? @TEXT("${name}", key="name", halign="middle") => @PLACE(-1, 1.6)
//     };
//   %port_1 = $IO_PORT @ATTACH &"Vcmo" => @PLACE(17, 16) => @ORIENT("R0");
//   %port_1 @SET-SYMBOL %input_port_symbol;
//   %port_1 @TEXT("Vcmo", key="name");
//   %port_2 = $IO_PORT @ATTACH &"Vinb" => @PLACE(-28, -9) => @ORIENT("R0");
//   %port_2 @SET-SYMBOL %input_port_symbol;
//   %port_2 @TEXT("Vinb", key="name");
//   %output_port_symbol = @DEFINE-SYMBOL(box=[0, -1, 2, 1]) {
//       @LINE(fill="linecolor", linestyle="none") {(0, -0.9) (0, 0.9) (1.1, 0.9) (2, 0) (1.1, -0.9) (0, -0.9)};
//       (0, 0) @PIN(terminal=1, direction="left");
//       ? @TEXT("${name}", key="name", halign="middle") => @PLACE(1, 1.6)
//     };
//   %port_3 = $IO_PORT @ATTACH &"Vout" => @PLACE(57, -14) => @ORIENT("R0");
//   %port_3 @SET-SYMBOL %output_port_symbol;
//   %port_3 @TEXT("Vout", key="name");
//   %port_4 = $IO_PORT @ATTACH &"Vin" => @PLACE(-28, 5) => @ORIENT("R0");
//   %port_4 @SET-SYMBOL %input_port_symbol;
//   %port_4 @TEXT("Vin", key="name");
//   %port_5 = $IO_PORT @ATTACH &"Voutb" => @PLACE(57, 10) => @ORIENT("R0");
//   %port_5 @SET-SYMBOL %output_port_symbol;
//   %port_5 @TEXT("Voutb", key="name");
//   %wire_0 = &"0" @WIRE(mode="straight") {%marker_9:p #"G1":2};
//   %wire_1 = &"0" @WIRE(mode="straight") {%marker_16:p #"I0":2};
//   %wire_2 = &"0" @WIRE(mode="straight") {%marker_1:p #"G3":2};
//   %p0 = (3, 10);
//   %wire_3 = &"Voutb" @WIRE(mode="straight") {#"G0":1 %p0};
//   %p1 = (25, 10);
//   %wire_4 = &"Voutb" @WIRE(mode="straight") {#"R0":1 %p1};
//   %p2 = (47, 10);
//   %wire_5 = &"Voutb" @WIRE(mode="straight") {%p1 %p2};
//   %wire_6 = &"Voutb" @WIRE(mode="straight") {%p2 %port_5:p};
//   %wire_7 = &"Voutb" @WIRE(mode="straight") {#"G1":1 %p2};
//   %wire_8 = &"Voutb" @WIRE(mode="straight") {%p0 %p1};
//   %p3 = (3, -14);
//   %wire_9 = &"Vout" @WIRE(mode="straight") {%p3 #"G0":2};
//   %p4 = (47, -14);
//   %wire_10 = &"Vout" @WIRE(mode="straight") {%p4 %port_3:p};
//   %p5 = (25, -14);
//   %wire_11 = &"Vout" @WIRE(mode="straight") {%p3 %p5};
//   %wire_12 = &"Vout" @WIRE(mode="straight") {%p5 #"R4":2};
//   %wire_13 = &"Vout" @WIRE(mode="straight") {%p5 %p4};
//   %wire_14 = &"Vout" @WIRE(mode="straight") {#"G3":1 %p4};
//   %p6 = (-21, -9);
//   %wire_15 = &"Vinb" @WIRE(mode="straight") {%port_2:p %p6};
//   %wire_16 = &"Vinb" @WIRE(mode="straight") {%p6 #"E4":1};
//   %p7 = (4, 32);
//   %wire_17 = &"Vdd" @WIRE(mode="straight") {#"I0":1 %p7};
//   %p8 = (1.5, 32);
//   %wire_18 = &"Vdd" @WIRE(mode="straight") {%p8 %port_0:p %p7};
//   %p9 = (22, 16);
//   %wire_19 = &"Vcmo" @WIRE(mode="straight") {%port_1:p %p9};
//   %p10 = (37, 2);
//   %wire_20 = &"Vcmo" @WIRE(mode="straight") {%p10 #"G1":4};
//   %p11 = (37, -22);
//   %wire_21 = &"Vcmo" @WIRE(mode="straight") {%p11 #"G3":4};
//   %wire_21 @TEXT("Vcmo", size=1, halign="middle", valign="baseline") => @PLACE(41, -21.3);
//   %wire_20 @TEXT("Vcmo", size=1, halign="middle", valign="baseline") => @PLACE(41, 2.7);
//   %wire_19 @TEXT("Vcmo", size=1, halign="middle", valign="baseline") => @PLACE(19, 16.7);
//   %p12 = (37, -20);
//   %wire_22 = &"Vcmo_int" @WIRE(mode="straight") {%p12 #"G3":3};
//   %p13 = (25, -2);
//   %wire_23 = &"Vcmo_int" @WIRE(mode="straight") {#"R4":1 %p13};
//   %p14 = (33, -2);
//   %wire_24 = &"Vcmo_int" @WIRE(mode="straight") {%p13 %p14};
//   %p15 = (37, 4);
//   %wire_25 = &"Vcmo_int" @WIRE(mode="straight") {%p15 #"G1":3};
//   %wire_26 = &"Vcmo_int" @WIRE(mode="straight") {%p13 #"R0":2};
//   %wire_22 @TEXT("Vcmo\_int", size=1, halign="middle", valign="baseline") => @PLACE(41, -19.3);
//   %wire_25 @TEXT("Vcmo\_int", size=1, halign="middle", valign="baseline") => @PLACE(41, 4.7);
//   %wire_24 @TEXT("Vcmo\_int", size=1, halign="middle", valign="baseline") => @PLACE(29, -1.3);
//   %p16 = (-10, -19);
//   %wire_27 = &"0" @WIRE(mode="straight") {%marker_6:p %p16};
//   %p17 = (-9, -19);
//   %wire_28 = &"0" @WIRE(mode="straight") {%p16 %p17};
//   %p18 = (-9, -13);
//   %wire_29 = &"0" @WIRE(mode="straight") {%p17 %p18};
//   %p19 = (-13, -13);
//   %wire_30 = &"0" @WIRE(mode="straight") {%p19 %p18};
//   %p20 = (-13, -11);
//   %wire_31 = &"0" @WIRE(mode="straight") {%p20 #"E4":3};
//   %p21 = (-5, -11);
//   %wire_32 = &"0" @WIRE(mode="straight") {#"E4":4 %p21};
//   %wire_33 = &"0" @WIRE(mode="straight") {%p19 %p20};
//   %wire_34 = &"0" @WIRE(mode="straight") {%marker_8:p %p21};
//   %p22 = (1, 5);
//   %wire_35 = &"Vin" @WIRE(mode="straight") {#"G0":3 %p22};
//   %p23 = (-21, 5);
//   %wire_36 = &"Vin" @WIRE(mode="straight") {%port_4:p %p23};
//   %wire_37 = &"Vin" @WIRE(mode="straight") {%p23 %p22};
//   %p24 = (1, -9);
//   %wire_38 = &"net023" @WIRE(mode="straight") {%p24 #"G0":4};
//   %wire_39 = &"net023" @WIRE(mode="straight") {#"E4":2 %p24};
//   $JUNCTION @ATTACH %p1;
//   $JUNCTION @ATTACH %p2;
//   $JUNCTION @ATTACH %p4;
//   $JUNCTION @ATTACH %p5;
//   $JUNCTION @ATTACH %p13;
//   (13, 4) @TEXT("Use differential input: gm -> gm/2", size=1, halign="middle", valign="baseline");
//   (27, 12) @TEXT("ro = Gain/gm", size=1, halign="middle", valign="baseline");
//   (-22, 8) @TEXT("Cox = gm/fT/2/pi", size=1, halign="middle", valign="baseline")
// }
// @RNL(author="native-ignored-figure-recovery") {
//   %ignored_symbol_0 = @DEFINE-SYMBOL(box=[-2, -6, 2, 0]) {
//     @LINE {(1, -2.2) (-1, -2.2)};
//     @LINE {(0, 0) (0, -2.2)};
//     @LINE {(0, -2.8) (0, -6)};
//     @ARC {(1, -3.2) (0, -2.8) (-1, -3.2)};
//     ? @TEXT("${name}", size=0.8, halign="start", valign="baseline", key="name") => @PLACE(1, -1);
//     (0, 0) @CIRCLE(radius=0.12);
//     (0, -6) @CIRCLE(radius=0.12)
//   };
//   %ignored_0 = $FIGURE @ATTACH (-21, 5) => @SET-SYMBOL %ignored_symbol_0 => @ORIENT("R0");
//   %ignored_0 @TEXT("C0", key="name");
//   %ignored_0 @TEXT("cap", key="model")
// }
// @RNL(author="native-ignored-figure-recovery") {
//   %ignored_symbol_1 = @DEFINE-SYMBOL(box=[-2, -6, 2, 0]) {
//     @LINE {(1, -2.2) (-1, -2.2)};
//     @LINE {(0, 0) (0, -2.2)};
//     @LINE {(0, -2.8) (0, -6)};
//     @ARC {(1, -3.2) (0, -2.8) (-1, -3.2)};
//     ? @TEXT("${name}", size=0.8, halign="start", valign="baseline", key="name") => @PLACE(1, -1);
//     (0, 0) @CIRCLE(radius=0.12);
//     (0, -6) @CIRCLE(radius=0.12)
//   };
//   %ignored_1 = $FIGURE @ATTACH (-21, -9) => @SET-SYMBOL %ignored_symbol_1 => @ORIENT("R0");
//   %ignored_1 @TEXT("C4", key="name");
//   %ignored_1 @TEXT("cap", key="model")
// }
// @RNL(author="native-ignored-figure-recovery") {
//   %ignored_symbol_2 = @DEFINE-SYMBOL(box=[-2, -6, 2, 0]) {
//     @LINE {(0, -6) (0, -4.8) (-1, -4.5) (1, -3.9) (-1, -3.3) (1, -2.7) (-1, -2.1) (1, -1.5) (0, -1.2) (0, 0)};
//     ? @TEXT("${name}", size=0.8, halign="start", valign="baseline", key="name") => @PLACE(1.5, -1);
//     (0, 0) @CIRCLE(radius=0.12);
//     (0, -6) @CIRCLE(radius=0.12)
//   };
//   %ignored_2 = $FIGURE @ATTACH (-13, -13) => @SET-SYMBOL %ignored_symbol_2 => @ORIENT("R0");
//   %ignored_2 @TEXT("R7", key="name");
//   %ignored_2 @TEXT("res", key="model")
// }
ends PIPE_OTA_Diff_Ideal
