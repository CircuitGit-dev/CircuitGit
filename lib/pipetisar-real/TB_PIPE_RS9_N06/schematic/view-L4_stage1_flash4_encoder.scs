// Explicit native hierarchy assembly; no automatic inclusion.
simulator lang=spectre
include "L4_stage1_flash4_encoder.scs"
