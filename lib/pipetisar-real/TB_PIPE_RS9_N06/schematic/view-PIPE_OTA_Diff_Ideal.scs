// Explicit native hierarchy assembly; no automatic inclusion.
simulator lang=spectre
include "PIPE_OTA_Diff_Ideal.scs"
