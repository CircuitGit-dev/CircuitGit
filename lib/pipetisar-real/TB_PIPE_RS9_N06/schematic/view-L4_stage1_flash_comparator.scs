// Explicit native hierarchy assembly; no automatic inclusion.
simulator lang=spectre
include "trans_ulvt_mac.scs"
include "L4_stage1_flash_comparator.scs"
