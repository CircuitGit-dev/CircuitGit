// RNL cell 2026_PIPETISAR_RESEARCH/RS9_L5_9bit_RSW_CDAC
// @RNL(type="header") {
//   @VERSION("0.3");
//   @USE-PACKAGE(name="rnl-std-spectre", version="0.3", path="rnl-std-spectre.rnl");
//   @USE-PACKAGE(name="eda-symbol", version="0.1", path="eda-symbol.rnl");
//   @USE-PACKAGE(name="eda-style", version="0.1", path="eda-style.rnl")
// }
subckt RS9_L5_9bit_RSW_CDAC BOT_9 BOT_8 BOT_7 BOT_6 BOT_5 BOT_4 BOT_3 \
        BOT_2 BOT_1 BOT_0 CLKBB DVDD DVSS RN_9 RN_8 RN_7 RN_6 RN_5 RN_4 \
        RN_3 RN_2 RN_1 RP_9 RP_8 RP_7 RP_6 RP_5 RP_4 RP_3 RP_2 RP_1 TOP \
        VBST VIN VREFN VREFP
    I4 (BOT_9 BOT_8 BOT_7 BOT_6 BOT_5 BOT_4 BOT_3 BOT_2 BOT_1 BOT_0 TOP \
        DVSS) RS9_L7_9bit_CDAC
    I3 (BOT_9 BOT_8 BOT_7 BOT_6 BOT_5 BOT_4 BOT_3 BOT_2 BOT_1 BOT_0 CLKBB \
        RN_9 RN_8 RN_7 RN_6 RN_5 RN_4 RN_3 RN_2 RN_1 RP_9 RP_8 RP_7 RP_6 \
        RP_5 RP_4 RP_3 RP_2 RP_1 VBST DVDD VIN VREFN VREFP DVSS) \
        RS9_L6_9bit_RSW
// @RNL(author="rnl-virtuoso") {
//   %block_symbol = @DEFINE-SYMBOL(box=[0, -16, 36, 11]) {
//     @LINE {(0, -4) (4, -4)};
//     @LINE {(0, -2) (4, -2)};
//     @LINE {(0, 0) (4, 0)};
//     @LINE {(36, -2) (32, -2)};
//     @LINE {(36, 0) (32, 0)};
//     @LINE {(16, 11) (16, 7)};
//     @LINE {(18, 11) (18, 7)};
//     @LINE {(20, 11) (20, 7)};
//     @LINE {(16, -16) (16, -12)};
//     @LINE {(18, -16) (18, -12)};
//     @LINE {(20, -16) (20, -12)};
//     @RECTANGLE {(4, -12) (32, 7)};
//     ? @TEXT("${name}", size=1, halign="start", valign="middle", key="name") => @PLACE(32, 7);
//     ? @TEXT("${model}", size=1, halign="middle", valign="middle", key="model") => @PLACE(18, -2.5);
//     (0, -4) @PIN(terminal="VIN");
//     (4.6, -4) @TEXT("VIN", size=1, halign="start", valign="middle");
//     (0, -2) @PIN(terminal=["RP_9", "RP_8", "RP_7", "RP_6", "RP_5", "RP_4", "RP_3", "RP_2", "RP_1"]);
//     (4.6, -2) @TEXT("RP<9:1>", size=1, halign="start", valign="middle");
//     (0, 0) @PIN(terminal=["RN_9", "RN_8", "RN_7", "RN_6", "RN_5", "RN_4", "RN_3", "RN_2", "RN_1"]);
//     (4.6, 0) @TEXT("RN<9:1>", size=1, halign="start", valign="middle");
//     (36, -2) @PIN(terminal=["BOT_9", "BOT_8", "BOT_7", "BOT_6", "BOT_5", "BOT_4", "BOT_3", "BOT_2", "BOT_1", "BOT_0"]);
//     (31.4, -2) @TEXT("BOT<9:0>", size=1, halign="end", valign="middle");
//     (36, 0) @PIN(terminal="TOP");
//     (31.4, 0) @TEXT("TOP", size=1, halign="end", valign="middle");
//     (16, 11) @PIN(terminal="DVDD");
//     (16, 6.4) @TEXT("DVDD", size=1, halign="end", valign="middle", rotate=90);
//     (18, 11) @PIN(terminal="VREFP");
//     (18, 6.4) @TEXT("VREFP", size=1, halign="end", valign="middle", rotate=90);
//     (20, 11) @PIN(terminal="VBST");
//     (20, 6.4) @TEXT("VBST", size=1, halign="end", valign="middle", rotate=90);
//     (16, -16) @PIN(terminal="DVSS");
//     (16, -11.4) @TEXT("DVSS", size=1, halign="start", valign="middle", rotate=90);
//     (18, -16) @PIN(terminal="VREFN");
//     (18, -11.4) @TEXT("VREFN", size=1, halign="start", valign="middle", rotate=90);
//     (20, -16) @PIN(terminal="CLKBB");
//     (20, -11.4) @TEXT("CLKBB", size=1, halign="start", valign="middle", rotate=90)
//   };
//   # @SET-SYMBOL %block_symbol;
//   #"I3" @PLACE(-58, -4) => @ORIENT("R0");
//   #"I4" @PLACE(-15, -4) => @ORIENT("MX");
//   %input_port_symbol = @DEFINE-SYMBOL(box=[-2, -1, 0, 1]) {
//       @LINE(fill="linecolor", linestyle="none") {(-2, -0.9) (-2, 0.9) (-0.9, 0.9) (0, 0) (-0.9, -0.9) (-2, -0.9)};
//       (0, 0) @PIN(terminal=1, direction="right");
//       ? @TEXT("${name}", key="name", halign="middle") => @PLACE(-1, 1.6)
//     };
//   %port_0 = $IO_PORT @ATTACH &"CLKBB" => @PLACE(-73, 14) => @ORIENT("R0");
//   %port_0 @SET-SYMBOL %input_port_symbol;
//   %port_0 @TEXT("CLKBB", key="name");
//   %bus_port_type_1 = @DEFINE(roles=[["p", "net"], ["p1", "net"], ["p2", "net"], ["p3", "net"], ["p4", "net"], ["p5", "net"], ["p6", "net"], ["p7", "net"], ["p8", "net"]]) {};
//   %bus_port_type_1_symbol = @DEFINE-SYMBOL {(0, 0) @PIN(terminal=[1, 2, 3, 4, 5, 6, 7, 8, 9])};
//   {&"RN_9" &"RN_8" &"RN_7" &"RN_6" &"RN_5" &"RN_4" &"RN_3" &"RN_2" &"RN_1"} @REMOVE-FROM $PORT_FILL_SET;
//   %port_1 = %bus_port_type_1 @ATTACH &"RN_9" &"RN_8" &"RN_7" &"RN_6" &"RN_5" &"RN_4" &"RN_3" &"RN_2" &"RN_1" => @PLACE(-73, 11) => @ORIENT("R0");
//   %port_1 @SET-SYMBOL %bus_port_type_1_symbol;
//   %port_1_marker = $IO_PORT @ATTACH &"RN_9" => @PLACE(-73, 11) => @ORIENT("R0");
//   %port_1_marker @SET-SYMBOL %input_port_symbol;
//   %port_1_marker @TEXT("RN<9:1>", key="name");
//   %bus_port_type_2 = @DEFINE(roles=[["p", "net"], ["p1", "net"], ["p2", "net"], ["p3", "net"], ["p4", "net"], ["p5", "net"], ["p6", "net"], ["p7", "net"], ["p8", "net"]]) {};
//   %bus_port_type_2_symbol = @DEFINE-SYMBOL {(0, 0) @PIN(terminal=[1, 2, 3, 4, 5, 6, 7, 8, 9])};
//   {&"RP_9" &"RP_8" &"RP_7" &"RP_6" &"RP_5" &"RP_4" &"RP_3" &"RP_2" &"RP_1"} @REMOVE-FROM $PORT_FILL_SET;
//   %port_2 = %bus_port_type_2 @ATTACH &"RP_9" &"RP_8" &"RP_7" &"RP_6" &"RP_5" &"RP_4" &"RP_3" &"RP_2" &"RP_1" => @PLACE(-73, 8) => @ORIENT("R0");
//   %port_2 @SET-SYMBOL %bus_port_type_2_symbol;
//   %port_2_marker = $IO_PORT @ATTACH &"RP_9" => @PLACE(-73, 8) => @ORIENT("R0");
//   %port_2_marker @SET-SYMBOL %input_port_symbol;
//   %port_2_marker @TEXT("RP<9:1>", key="name");
//   %port_3 = $IO_PORT @ATTACH &"VIN" => @PLACE(-73, 5) => @ORIENT("R0");
//   %port_3 @SET-SYMBOL %input_port_symbol;
//   %port_3 @TEXT("VIN", key="name");
//   %port_4 = $IO_PORT @ATTACH &"DVDD" => @PLACE(-74, 2) => @ORIENT("R0");
//   %port_5 = $IO_PORT @ATTACH &"DVSS" => @PLACE(-74, -1) => @ORIENT("R0");
//   %port_6 = $IO_PORT @ATTACH &"VREFP" => @PLACE(-74, -4) => @ORIENT("R0");
//   %port_7 = $IO_PORT @ATTACH &"VREFN" => @PLACE(-74, -7) => @ORIENT("R0");
//   %port_8 = $IO_PORT @ATTACH &"VBST" => @PLACE(-73, -10) => @ORIENT("R0");
//   %port_8 @SET-SYMBOL %input_port_symbol;
//   %port_8 @TEXT("VBST", key="name");
//   %bus_port_type_9 = @DEFINE(roles=[["p", "net"], ["p1", "net"], ["p2", "net"], ["p3", "net"], ["p4", "net"], ["p5", "net"], ["p6", "net"], ["p7", "net"], ["p8", "net"], ["p9", "net"]]) {};
//   %bus_port_type_9_symbol = @DEFINE-SYMBOL {(0, 0) @PIN(terminal=[1, 2, 3, 4, 5, 6, 7, 8, 9, 10])};
//   {&"BOT_9" &"BOT_8" &"BOT_7" &"BOT_6" &"BOT_5" &"BOT_4" &"BOT_3" &"BOT_2" &"BOT_1" &"BOT_0"} @REMOVE-FROM $PORT_FILL_SET;
//   %port_9 = %bus_port_type_9 @ATTACH &"BOT_9" &"BOT_8" &"BOT_7" &"BOT_6" &"BOT_5" &"BOT_4" &"BOT_3" &"BOT_2" &"BOT_1" &"BOT_0" => @PLACE(-74, -13) => @ORIENT("R0");
//   %port_9 @SET-SYMBOL %bus_port_type_9_symbol;
//   %port_9_marker = $IO_PORT @ATTACH &"BOT_9" => @PLACE(-74, -13) => @ORIENT("R0");
//   %port_9_marker @TEXT("BOT<9:0>", key="name");
//   %port_10 = $IO_PORT @ATTACH &"TOP" => @PLACE(-74, -16) => @ORIENT("R0");
//   %p0 = (23, -4);
//   %wire_0 = &"TOP" @WIRE(mode="straight") {#"I4":11 %p0};
//   %wire_0 @TEXT("TOP", size=1, halign="start", valign="top") => @PLACE(18.4, -4.7);
//   %wire_1 = {&"BOT_9" &"BOT_8" &"BOT_7" &"BOT_6" &"BOT_5" &"BOT_4" &"BOT_3" &"BOT_2" &"BOT_1" &"BOT_0"} @WIRE(mode="straight") {#"I3":1 #"I4":1};
//   %wire_1 @TEXT("BOT<9:0>", size=1, halign="start", valign="top") => @PLACE(-21.6, -4.7);
//   %p1 = (-38, 11);
//   %wire_2 = &"VBST" @WIRE(mode="straight") {#"I3":30 %p1};
//   %wire_2 @TEXT("VBST", size=1, halign="start", valign="baseline", rotate=90) => @PLACE(-38.7, 7.4);
//   %p2 = (-40, -26);
//   %wire_3 = &"VREFN" @WIRE(mode="straight") {%p2 #"I3":33};
//   %wire_3 @TEXT("VREFN", size=1, halign="end", valign="baseline", rotate=90) => @PLACE(-40.7, -22.4);
//   %p3 = (-40, 11);
//   %wire_4 = &"VREFP" @WIRE(mode="straight") {#"I3":34 %p3};
//   %wire_4 @TEXT("VREFP", size=1, halign="start", valign="baseline", rotate=90) => @PLACE(-40.7, 7.4);
//   %p4 = (1, 9);
//   %wire_5 = &"DVSS" @WIRE(mode="straight") {%p4 #"I4":12};
//   %p5 = (-42, -26);
//   %wire_6 = &"DVSS" @WIRE(mode="straight") {%p5 #"I3":35};
//   %wire_6 @TEXT("DVSS", size=1, halign="end", valign="baseline", rotate=90) => @PLACE(-42.7, -22.4);
//   %wire_5 @TEXT("DVSS", size=1, halign="start", valign="baseline", rotate=90) => @PLACE(0.3, 5.4);
//   %p6 = (-42, 11);
//   %wire_7 = &"DVDD" @WIRE(mode="straight") {#"I3":31 %p6};
//   %wire_7 @TEXT("DVDD", size=1, halign="start", valign="baseline", rotate=90) => @PLACE(-42.7, 7.4);
//   %p7 = (-62, -10);
//   %wire_8 = &"VIN" @WIRE(mode="straight") {%p7 #"I3":32};
//   %wire_8 @TEXT("VIN", size=1, halign="end", valign="baseline") => @PLACE(-58.4, -9.3);
//   %p8 = (-62, -8);
//   %wire_9 = {&"RP_9" &"RP_8" &"RP_7" &"RP_6" &"RP_5" &"RP_4" &"RP_3" &"RP_2" &"RP_1"} @WIRE(mode="straight") {%p8 #"I3":21};
//   %wire_9 @TEXT("RP<9:1>", size=1, halign="end", valign="baseline") => @PLACE(-62.4, -7.8);
//   %p9 = (-62, -6);
//   %wire_10 = {&"RN_9" &"RN_8" &"RN_7" &"RN_6" &"RN_5" &"RN_4" &"RN_3" &"RN_2" &"RN_1"} @WIRE(mode="straight") {%p9 #"I3":12};
//   %wire_10 @TEXT("RN<9:1>", size=1, halign="end", valign="baseline") => @PLACE(-62.4, -5.8);
//   %p10 = (-62, -4);
//   %wire_11 = &"CLKBB" @WIRE(mode="straight") {%p10 #"I3":11};
//   %wire_11 @TEXT("CLKBB", size=1, halign="end", valign="baseline") => @PLACE(-58.4, -3.3);
//   (0, -80) @TEXT("PRE-LAYOUT: CDAC I4 enabled. Source schematic ignored it for extracted-view operation.", size=2.7, halign="start", valign="baseline")
// }
ends RS9_L5_9bit_RSW_CDAC
