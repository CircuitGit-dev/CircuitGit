// RNL cell 2026_PIPETISAR_RESEARCH/RS9_L6_SR_latch_1
// @RNL(type="header") {
//   @VERSION("0.3");
//   @USE-PACKAGE(name="rnl-std-spectre", version="0.3", path="rnl-std-spectre.rnl");
//   @USE-PACKAGE(name="eda-symbol", version="0.1", path="eda-symbol.rnl");
//   @USE-PACKAGE(name="eda-style", version="0.1", path="eda-style.rnl")
// }
subckt RS9_L6_SR_latch_1 CLK COMPN COMPP D DON DOP ENB NEXTB RDY RST VDD \
        VSS
    I15 (DOP CLK D VDD VSS) DFQD1BWP12T30P140LVT
    I4 (RDY NEXTB net11 VDD VSS) ND2D0BWP12T30P140LVT
    I5 (net11 EN NEXTB VDD VSS) ND2D0BWP12T30P140LVT
    I6 (net8 net2 EN VDD VSS) ND2D0BWP12T30P140LVT
    I12 (L net1 net2 VDD VSS) NR2D1BWP12T30P140LVT
    I2 (R net7 net8 VDD VSS) NR2D1BWP12T30P140LVT
    I0 (COMPN EN_SELF R VDD VSS) AN2D0BWP12T30P140LVT
    I13 (COMPP EN_SELF L VDD VSS) AN2D0BWP12T30P140LVT
    I3 (RST net8 net7 VDD VSS) NR2D0BWP12T30P140LVT
    I7 (ENB EN EN_SELF VDD VSS) NR2D0BWP12T30P140LVT
    I10 (RST net2 net1 VDD VSS) NR2D0BWP12T30P140LVT
    I11 (net2 DON VDD VSS) INVD2BWP12T30P140LVT
    I39 (net8 DOP VDD VSS) INVD2BWP12T30P140LVT
// @RNL(author="rnl-virtuoso") {
//   %block_symbol = @DEFINE-SYMBOL(box=[9, -8, 29, 2]) {
//     @LINE {(5, -2) (9, -2)};
//     @LINE {(5, -4) (9, -4)};
//     @LINE {(18, 6) (18, 2)};
//     @LINE {(20, 6) (20, 2)};
//     @LINE {(33, -4) (29, -4)};
//     @LINE {(33, -2) (29, -2)};
//     @LINE {(33, 0) (29, 0)};
//     @LINE {(14, 6) (14, 2)};
//     @RECTANGLE {(9, -8) (29, 2)};
//     @LINE {(14, -12) (14, -8)};
//     @LINE {(24, 6) (24, 2)};
//     @LINE {(5, 0) (9, 0)};
//     @LINE {(33, -6) (29, -6)};
//     (18.5, -3) @TEXT("SR\_Latch", size=1, halign="middle", valign="middle");
//     (5, -2) @PIN(terminal="RST");
//     (9.6, -2) @TEXT("RST", size=1, halign="start", valign="middle");
//     (5, -4) @PIN(terminal="ENB");
//     (9.6, -4) @TEXT("ENB", size=1, halign="start", valign="middle");
//     (18, 6) @PIN(terminal="COMPP");
//     (16, 7.4) @TEXT("COMPP", size=1, halign="end", valign="middle", rotate=90);
//     (20, 6) @PIN(terminal="COMPN");
//     (22, 7.4) @TEXT("COMPN", size=1, halign="end", valign="middle", rotate=90);
//     (33, -4) @PIN(terminal="NEXTB");
//     (28.4, -4) @TEXT("NEXTB", size=1, halign="end", valign="middle");
//     (33, -2) @PIN(terminal="DOP");
//     (28.4, -2) @TEXT("DOP", size=1, halign="end", valign="middle");
//     (33, 0) @PIN(terminal="DON");
//     (28.4, 0) @TEXT("DON", size=1, halign="end", valign="middle");
//     (14, 6) @PIN(terminal="VDD");
//     (13, 5.4) @TEXT("VDD", size=1, halign="end", valign="middle", rotate=90);
//     (14, -12) @PIN(terminal="VSS");
//     (13, -11.4) @TEXT("VSS", size=1, halign="start", valign="middle", rotate=90);
//     (5, 0) @PIN(terminal="CLK");
//     (9.6, 0) @TEXT("CLK", size=1, halign="start", valign="middle");
//     (24, 6) @PIN(terminal="RDY");
//     (26, 5.4) @TEXT("RDY", size=1, halign="end", valign="middle", rotate=90);
//     (33, -6) @PIN(terminal="D");
//     (28.4, -6) @TEXT("D", size=1, halign="end", valign="middle");
//     ? @TEXT("${name}", key="name") => @PLACE(0, 1)
//   };
//   # @SET-SYMBOL %block_symbol;
//   %symbol_0 = @DEFINE-SYMBOL(box=[8, -3, 17, 5]) {
//     (15.5, 1) @CIRCLE(radius=0.5);
//     @LINE {(12, 5) (12, 3)};
//     @LINE {(16, 1) (17, 1)};
//     @LINE {(12, -3) (12, -1)};
//     @LINE {(9, 3) (12, 3)};
//     @LINE {(9, -1) (12, -1)};
//     @ARC {(9, -1) (11, 1) (9, 3)};
//     @LINE {(8, 2) (10.7, 2)};
//     @LINE {(8, 0) (10.7, 0)};
//     @ARC {(14.9, 0.9) (13.8, 2.4) (12, 2.9)};
//     @ARC {(12, -1) (13.8, -0.5) (15, 1)};
//     ? @TEXT("${name}", size=0.4, halign="end", valign="top", key="name") => @PLACE(17, 5);
//     ? @TEXT("${model}", size=0.4, halign="end", valign="baseline", key="model") => @PLACE(17, -3);
//     (12, -3) @PIN(terminal=5);
//     (12.9, -3) @TEXT("VSS", size=0.4, halign="start", valign="middle");
//     (17, 1) @PIN(terminal=3);
//     (14.6, 1) @TEXT("ZN", size=0.4, halign="end", valign="middle");
//     (12, 5) @PIN(terminal=4);
//     (12.9, 5) @TEXT("VDD", size=0.4, halign="start", valign="middle");
//     (8, 2) @PIN(terminal=1);
//     (11.4, 2) @TEXT("A1", size=0.4, halign="start", valign="middle");
//     (8, 0) @PIN(terminal=2);
//     (11.4, 0) @TEXT("A2", size=0.4, halign="start", valign="middle")
//   };
//   #"I7" @SET-SYMBOL %symbol_0;
//   #"I7" @PLACE(1, 6) => @ORIENT("MY");
//   #"I10" @SET-SYMBOL %symbol_0;
//   #"I10" @PLACE(-10, -10) => @ORIENT("MX");
//   %symbol_1 = @DEFINE-SYMBOL(box=[-9, -3, 0, 5]) {
//     @LINE {(-6, 5) (-6, 3)};
//     @LINE {(-2, 1) (-1, 1)};
//     @LINE {(-6, -3) (-6, -1)};
//     @LINE {(-7, 3) (-7, -1)};
//     @LINE {(-7, 3) (-5, 3)};
//     @LINE {(-7, -1) (-5, -1)};
//     @ARC {(-5, -1) (-3, 1) (-5, 3)};
//     @LINE {(-9, 2) (-7, 2)};
//     @LINE {(-9, 0) (-7, 0)};
//     @LINE {(-1, 1) (0, 1)};
//     (-2.5, 1) @CIRCLE(radius=0.5);
//     ? @TEXT("${name}", size=0.4, halign="end", valign="top", key="name") => @PLACE(0, 5);
//     ? @TEXT("${model}", size=0.4, halign="end", valign="baseline", key="model") => @PLACE(0, -3);
//     (0, 1) @PIN(terminal=3);
//     (-3.4, 1) @TEXT("ZN", size=0.4, halign="end", valign="middle");
//     (-6, -3) @PIN(terminal=5);
//     (-5.1, -3) @TEXT("VSS", size=0.4, halign="start", valign="middle");
//     (-6, 5) @PIN(terminal=4);
//     (-5.1, 5) @TEXT("VDD", size=0.4, halign="start", valign="middle");
//     (-9, 2) @PIN(terminal=1);
//     (-6.6, 2) @TEXT("A1", size=0.4, halign="start", valign="middle");
//     (-9, 0) @PIN(terminal=2);
//     (-6.6, 0) @TEXT("A2", size=0.4, halign="start", valign="middle")
//   };
//   #"I6" @SET-SYMBOL %symbol_1;
//   #"I6" @PLACE(15, 5) => @ORIENT("MY");
//   #"I3" @SET-SYMBOL %symbol_0;
//   #"I3" @PLACE(-10, 49) => @ORIENT("R0");
//   %symbol_2 = @DEFINE-SYMBOL(box=[8, -3, 17, 5]) {
//     (15.5, 1) @CIRCLE(radius=0.5);
//     @LINE {(12, 5) (12, 3)};
//     @LINE {(16, 1) (17, 1)};
//     @LINE {(12, -3) (12, -1)};
//     @LINE {(9, 3) (12, 3)};
//     @LINE {(9, -1) (12, -1)};
//     @ARC {(9, -1) (11, 1) (9, 3)};
//     @LINE {(8, 2) (10.7, 2)};
//     @LINE {(8, 0) (10.7, 0)};
//     @ARC {(14.9, 0.9) (13.8, 2.4) (12, 2.9)};
//     @ARC {(12, -1) (13.8, -0.5) (15, 1)};
//     ? @TEXT("${name}", size=0.4, halign="end", valign="top", key="name") => @PLACE(17, 5);
//     ? @TEXT("${model}", size=0.4, halign="end", valign="baseline", key="model") => @PLACE(17, -3);
//     (12, -3) @PIN(terminal=5);
//     (12.9, -3) @TEXT("VSS", size=0.4, halign="start", valign="middle");
//     (17, 1) @PIN(terminal=3);
//     (14.6, 1) @TEXT("ZN", size=0.4, halign="end", valign="middle");
//     (12, 5) @PIN(terminal=4);
//     (12.9, 5) @TEXT("VDD", size=0.4, halign="start", valign="middle");
//     (8, 2) @PIN(terminal=1);
//     (11.4, 2) @TEXT("A1", size=0.4, halign="start", valign="middle");
//     (8, 0) @PIN(terminal=2);
//     (11.4, 0) @TEXT("A2", size=0.4, halign="start", valign="middle")
//   };
//   #"I12" @SET-SYMBOL %symbol_2;
//   #"I12" @PLACE(-10, -29) => @ORIENT("MX");
//   #"I5" @SET-SYMBOL %symbol_1;
//   #"I5" @PLACE(19, 20) => @ORIENT("R0");
//   %symbol_3 = @DEFINE-SYMBOL(box=[-6, -5, 2, 3]) {
//     @LINE {(-6, -2) (-4, -2)};
//     @LINE {(-6, 0) (-4, 0)};
//     @ARC {(-2, -3) (0, -1) (-2, 1)};
//     @LINE {(-4, -3) (-2, -3)};
//     @LINE {(-4, 1) (-2, 1)};
//     @LINE {(-4, 1) (-4, -3)};
//     @LINE {(-3, -5) (-3, -3)};
//     @LINE {(0, -1) (2, -1)};
//     @LINE {(-3, 3) (-3, 1)};
//     ? @TEXT("${model}", size=0.4, halign="end", valign="baseline", key="model") => @PLACE(2, -5);
//     ? @TEXT("${name}", size=0.4, halign="end", valign="top", key="name") => @PLACE(2, 3);
//     (-3, -5) @PIN(terminal=5);
//     (-2.1, -5) @TEXT("VSS", size=0.4, halign="start", valign="middle");
//     (-3, 3) @PIN(terminal=4);
//     (-2.1, 3) @TEXT("VDD", size=0.4, halign="start", valign="middle");
//     (2, -1) @PIN(terminal=3);
//     (-0.4, -1) @TEXT("Z", size=0.4, halign="end", valign="middle");
//     (-6, 0) @PIN(terminal=1);
//     (-3.6, 0) @TEXT("A1", size=0.4, halign="start", valign="middle");
//     (-6, -2) @PIN(terminal=2);
//     (-3.6, -2) @TEXT("A2", size=0.4, halign="start", valign="middle")
//   };
//   #"I13" @SET-SYMBOL %symbol_3;
//   #"I13" @PLACE(-19, -32) => @ORIENT("MX");
//   #"I0" @SET-SYMBOL %symbol_3;
//   #"I0" @PLACE(-19, 71) => @ORIENT("R0");
//   %symbol_4 = @DEFINE-SYMBOL(box=[12, -1, 20, 9]) {
//     @LINE {(12, 2) (14, 2)};
//     @LINE {(14, 6) (12, 6)};
//     @LINE {(16, 9) (16, 8)};
//     @LINE {(16, 0) (16, -1)};
//     @LINE {(14, 8) (14, 0)};
//     @LINE {(14, 3) (15.4, 2) (14, 1)};
//     @LINE {(18, 8) (18, 0)};
//     @LINE {(14, 8) (18, 8)};
//     @LINE {(14, 0) (18, 0)};
//     @LINE {(20, 4) (18, 4)};
//     ? @TEXT("${model}", size=0.4, halign="end", valign="baseline", key="model") => @PLACE(20, -1);
//     ? @TEXT("${name}", size=0.4, halign="end", valign="top", key="name") => @PLACE(20, 9);
//     (16, -1) @PIN(terminal=5);
//     (14.4, -1) @TEXT("VSS", size=0.4, halign="start", valign="middle");
//     (16, 9) @PIN(terminal=4);
//     (14.4, 9) @TEXT("VDD", size=0.4, halign="start", valign="middle");
//     (20, 4) @PIN(terminal=3);
//     (17.9, 4) @TEXT("Q", size=0.4, halign="end", valign="middle");
//     (12, 6) @PIN(terminal=1);
//     (14.4, 6) @TEXT("D", size=0.4, halign="start", valign="middle");
//     (12, 2) @PIN(terminal=2);
//     (14.1, 2) @TEXT("CP", size=0.4, halign="start", valign="middle")
//   };
//   #"I15" @SET-SYMBOL %symbol_4;
//   #"I15" @PLACE(58, 23) => @ORIENT("R0");
//   #"I2" @SET-SYMBOL %symbol_2;
//   #"I2" @PLACE(-10, 68) => @ORIENT("R0");
//   #"I4" @SET-SYMBOL %symbol_1;
//   #"I4" @PLACE(18, 37) => @ORIENT("R0");
//   %symbol_5 = @DEFINE-SYMBOL(box=[-8, -8, -1, -2]) {
//     @LINE {(-6, -3) (-6, -7)};
//     @LINE {(-8, -5) (-6, -5)};
//     @LINE {(-6, -3) (-3, -5)};
//     @LINE {(-6, -7) (-3, -5)};
//     @LINE {(-2, -5) (-1, -5)};
//     @LINE {(-5, -2) (-5, -3.7)};
//     @LINE {(-5, -8) (-5, -6.4)};
//     (-2.5, -5) @CIRCLE(radius=0.5);
//     ? @TEXT("${model}", size=0.4, halign="end", valign="baseline", key="model") => @PLACE(-1, -8);
//     ? @TEXT("${name}", size=0.4, halign="end", valign="top", key="name") => @PLACE(-1, -2);
//     (-5, -8) @PIN(terminal=4);
//     (-4.1, -8) @TEXT("VSS", size=0.4, halign="start", valign="middle");
//     (-5, -2) @PIN(terminal=3);
//     (-4.1, -2) @TEXT("VDD", size=0.4, halign="start", valign="middle");
//     (-1, -5) @PIN(terminal=2);
//     (-3.4, -5) @TEXT("ZN", size=0.4, halign="end", valign="middle");
//     (-8, -5) @PIN(terminal=1);
//     (-5.8, -5) @TEXT("I", size=0.4, halign="start", valign="middle")
//   };
//   #"I39" @SET-SYMBOL %symbol_5;
//   #"I39" @PLACE(48, 74) => @ORIENT("R0");
//   #"I11" @SET-SYMBOL %symbol_5;
//   #"I11" @PLACE(48, -35) => @ORIENT("MX");
//   %input_port_symbol = @DEFINE-SYMBOL(box=[-2, -1, 0, 1]) {
//       @LINE(fill="linecolor", linestyle="none") {(-2, -0.9) (-2, 0.9) (-0.9, 0.9) (0, 0) (-0.9, -0.9) (-2, -0.9)};
//       (0, 0) @PIN(terminal=1, direction="right");
//       ? @TEXT("${name}", key="name", halign="middle") => @PLACE(-1, 1.6)
//     };
//   %port_0 = $IO_PORT @ATTACH &"COMPN" => @PLACE(-47, 71) => @ORIENT("R0");
//   %port_0 @SET-SYMBOL %input_port_symbol;
//   %port_0 @TEXT("COMPN", key="name");
//   %output_port_symbol = @DEFINE-SYMBOL(box=[0, -1, 2, 1]) {
//       @LINE(fill="linecolor", linestyle="none") {(0, -0.9) (0, 0.9) (1.1, 0.9) (2, 0) (1.1, -0.9) (0, -0.9)};
//       (0, 0) @PIN(terminal=1, direction="left");
//       ? @TEXT("${name}", key="name", halign="middle") => @PLACE(1, 1.6)
//     };
//   %port_1 = $IO_PORT @ATTACH &"DON" => @PLACE(49, -30) => @ORIENT("R0");
//   %port_1 @SET-SYMBOL %output_port_symbol;
//   %port_1 @TEXT("DON", key="name");
//   %port_2 = $IO_PORT @ATTACH &"ENB" => @PLACE(-35, 19) => @ORIENT("R0");
//   %port_2 @SET-SYMBOL %input_port_symbol;
//   %port_2 @TEXT("ENB", key="name");
//   %port_3 = $IO_PORT @ATTACH &"NEXTB" => @PLACE(49, 21) => @ORIENT("R0");
//   %port_3 @SET-SYMBOL %output_port_symbol;
//   %port_3 @TEXT("NEXTB", key="name");
//   %port_4 = $IO_PORT @ATTACH &"RST" => @PLACE(-35, 51) => @ORIENT("R0");
//   %port_4 @SET-SYMBOL %input_port_symbol;
//   %port_4 @TEXT("RST", key="name");
//   %port_5 = $IO_PORT @ATTACH &"DOP" => @PLACE(49, 69) => @ORIENT("R0");
//   %port_5 @SET-SYMBOL %output_port_symbol;
//   %port_5 @TEXT("DOP", key="name");
//   %port_6 = $IO_PORT @ATTACH &"COMPP" => @PLACE(-47, -32) => @ORIENT("R0");
//   %port_6 @SET-SYMBOL %input_port_symbol;
//   %port_6 @TEXT("COMPP", key="name");
//   %port_7 = $IO_PORT @ATTACH &"VDD" => @PLACE(-54, 28) => @ORIENT("R0");
//   %port_7 @SET-SYMBOL %input_port_symbol;
//   %port_7 @TEXT("VDD", key="name");
//   %port_8 = $IO_PORT @ATTACH &"VSS" => @PLACE(-54, 24) => @ORIENT("R0");
//   %port_8 @SET-SYMBOL %input_port_symbol;
//   %port_8 @TEXT("VSS", key="name");
//   %port_9 = $IO_PORT @ATTACH &"RDY" => @PLACE(-35, 39) => @ORIENT("R0");
//   %port_9 @SET-SYMBOL %input_port_symbol;
//   %port_9 @TEXT("RDY", key="name");
//   %port_10 = $IO_PORT @ATTACH &"CLK" => @PLACE(-54, 20) => @ORIENT("R0");
//   %port_10 @SET-SYMBOL %input_port_symbol;
//   %port_10 @TEXT("CLK", key="name");
//   %port_11 = $IO_PORT @ATTACH &"D" => @PLACE(-56, 17) => @ORIENT("R0");
//   %port_11 @SET-SYMBOL %output_port_symbol;
//   %port_11 @TEXT("D", key="name");
//   %p0 = (4, 22);
//   %wire_0 = &"net11" @WIRE(mode="straight") {%p0 #"I5":1};
//   %p1 = (4, 31);
//   %wire_1 = &"net11" @WIRE(mode="straight") {%p0 %p1};
//   %p2 = (25, 31);
//   %wire_2 = &"net11" @WIRE(mode="straight") {%p1 %p2};
//   %p3 = (25, 38);
//   %wire_3 = &"net11" @WIRE(mode="straight") {#"I4":3 %p3};
//   %wire_4 = &"net11" @WIRE(mode="straight") {%p2 %p3};
//   %p4 = (66, 25);
//   %wire_5 = &"CLK" @WIRE(mode="straight") {%p4 #"I15":2};
//   %wire_5 @TEXT("CLK", size=1, halign="end", valign="baseline") => @PLACE(69.6, 25.7);
//   %p5 = (82, 27);
//   %wire_6 = &"D" @WIRE(mode="straight") {#"I15":3 %p5};
//   %wire_6 @TEXT("D", size=1, halign="start", valign="baseline") => @PLACE(78.4, 27.7);
//   %p6 = (40, 7);
//   %wire_7 = &"net8" @WIRE(mode="straight") {%p6 #"I39":1};
//   %wire_8 = &"net8" @WIRE(mode="straight") {#"I6":1 %p6};
//   %p7 = (20, 69);
//   %wire_9 = &"net8" @WIRE(mode="straight") {%p7 #"I39":1};
//   %p8 = (20, 57);
//   %wire_10 = &"net8" @WIRE(mode="straight") {%p8 %p7};
//   %wire_11 = &"net8" @WIRE(mode="straight") {#"I2":3 %p7};
//   %p9 = (-12, 57);
//   %wire_12 = &"net8" @WIRE(mode="straight") {%p9 %p8};
//   %p10 = (-12, 49);
//   %wire_13 = &"net8" @WIRE(mode="straight") {%p10 #"I3":2};
//   %wire_14 = &"net8" @WIRE(mode="straight") {%p10 %p9};
//   %p11 = (22, 50);
//   %p12 = (22, 60);
//   %wire_15 = &"net7" @WIRE(mode="straight") {%p11 %p12};
//   %p13 = (-12, 60);
//   %wire_16 = &"net7" @WIRE(mode="straight") {%p13 %p12};
//   %wire_17 = &"net7" @WIRE(mode="straight") {#"I3":3 %p11};
//   %p14 = (-12, 68);
//   %wire_18 = &"net7" @WIRE(mode="straight") {%p14 #"I2":2};
//   %wire_19 = &"net7" @WIRE(mode="straight") {%p13 %p14};
//   %wire_20 = &"L" @WIRE(mode="straight") {#"I13":3 #"I12":1};
//   %wire_20 @TEXT("L", size=1, halign="middle", valign="baseline") => @PLACE(-9, -33.3);
//   %p15 = (40, 5);
//   %wire_21 = &"net2" @WIRE(mode="straight") {#"I11":1 %p15};
//   %wire_22 = &"net2" @WIRE(mode="straight") {#"I6":2 %p15};
//   %p16 = (20, -30);
//   %wire_23 = &"net2" @WIRE(mode="straight") {%p16 #"I11":1};
//   %wire_24 = &"net2" @WIRE(mode="straight") {#"I12":3 %p16};
//   %p17 = (-12, -18);
//   %p18 = (-12, -10);
//   %wire_25 = &"net2" @WIRE(mode="straight") {%p17 %p18};
//   %p19 = (20, -18);
//   %wire_26 = &"net2" @WIRE(mode="straight") {%p19 %p16};
//   %wire_27 = &"net2" @WIRE(mode="straight") {%p18 #"I10":2};
//   %wire_28 = &"net2" @WIRE(mode="straight") {%p17 %p19};
//   %p20 = (22, -11);
//   %wire_29 = &"net1" @WIRE(mode="straight") {#"I10":3 %p20};
//   %p21 = (22, -21);
//   %wire_30 = &"net1" @WIRE(mode="straight") {%p20 %p21};
//   %p22 = (-12, -21);
//   %wire_31 = &"net1" @WIRE(mode="straight") {%p22 %p21};
//   %p23 = (-12, -29);
//   %wire_32 = &"net1" @WIRE(mode="straight") {%p22 %p23};
//   %wire_33 = &"net1" @WIRE(mode="straight") {%p23 #"I12":2};
//   %p24 = (21, -2);
//   %wire_34 = &"VSS" @WIRE(mode="straight") {%p24 #"I6":5};
//   %p25 = (43, -25);
//   %wire_35 = &"VSS" @WIRE(mode="straight") {%p25 #"I11":4};
//   %p26 = (12, 32);
//   %wire_36 = &"VSS" @WIRE(mode="straight") {%p26 #"I4":5};
//   %p27 = (13, 15);
//   %wire_37 = &"VSS" @WIRE(mode="straight") {%p27 #"I5":5};
//   %p28 = (2, 63);
//   %wire_38 = &"VSS" @WIRE(mode="straight") {%p28 #"I2":5};
//   %p29 = (2, 44);
//   %wire_39 = &"VSS" @WIRE(mode="straight") {%p29 #"I3":5};
//   %p30 = (-11, 0);
//   %wire_40 = &"VSS" @WIRE(mode="straight") {%p30 #"I7":5};
//   %p31 = (2, -24);
//   %wire_41 = &"VSS" @WIRE(mode="straight") {%p31 #"I12":5};
//   %p32 = (-22, 64);
//   %wire_42 = &"VSS" @WIRE(mode="straight") {%p32 #"I0":5};
//   %p33 = (2, -5);
//   %wire_43 = &"VSS" @WIRE(mode="straight") {%p33 #"I10":5};
//   %p34 = (74, 18);
//   %wire_44 = &"VSS" @WIRE(mode="straight") {%p34 #"I15":5};
//   %p35 = (-22, -25);
//   %wire_45 = &"VSS" @WIRE(mode="straight") {%p35 #"I13":5};
//   %p36 = (43, 64);
//   %wire_46 = &"VSS" @WIRE(mode="straight") {%p36 #"I39":4};
//   %wire_43 @TEXT("VSS", size=1, halign="middle", valign="baseline", rotate=90) => @PLACE(1.3, -6);
//   %wire_46 @TEXT("VSS", size=1, halign="middle", valign="baseline", rotate=90) => @PLACE(42.3, 64);
//   %wire_44 @TEXT("VSS", size=1, halign="end", valign="baseline", rotate=90) => @PLACE(73.3, 21.6);
//   %wire_45 @TEXT("VSS", size=1, halign="middle", valign="baseline", rotate=90) => @PLACE(-22.7, -25);
//   %wire_42 @TEXT("VSS", size=1, halign="middle", valign="baseline", rotate=90) => @PLACE(-22.7, 64);
//   %wire_40 @TEXT("VSS", size=1, halign="middle", valign="baseline", rotate=90) => @PLACE(-11.7, 1);
//   %wire_39 @TEXT("VSS", size=1, halign="middle", valign="baseline", rotate=90) => @PLACE(1.3, 45);
//   %wire_38 @TEXT("VSS", size=1, halign="middle", valign="baseline", rotate=90) => @PLACE(1.3, 63);
//   %wire_37 @TEXT("VSS", size=1, halign="middle", valign="baseline", rotate=90) => @PLACE(12.3, 15);
//   %wire_36 @TEXT("VSS", size=1, halign="middle", valign="baseline", rotate=90) => @PLACE(11.3, 32);
//   %wire_35 @TEXT("VSS", size=1, halign="middle", valign="baseline", rotate=90) => @PLACE(42.3, -25);
//   %wire_34 @TEXT("VSS", size=1, halign="middle", valign="baseline", rotate=90) => @PLACE(20.3, 0);
//   %wire_41 @TEXT("VSS", size=1, halign="middle", valign="baseline", rotate=90) => @PLACE(1.3, -24);
//   %p37 = (21, 13);
//   %wire_47 = &"VDD" @WIRE(mode="straight") {#"I6":4 %p37};
//   %p38 = (-22, -37);
//   %wire_48 = &"VDD" @WIRE(mode="straight") {#"I13":4 %p38};
//   %p39 = (43, -35);
//   %wire_49 = &"VDD" @WIRE(mode="straight") {#"I11":3 %p39};
//   %p40 = (12, 44);
//   %wire_50 = &"VDD" @WIRE(mode="straight") {#"I4":4 %p40};
//   %p41 = (13, 27);
//   %wire_51 = &"VDD" @WIRE(mode="straight") {#"I5":4 %p41};
//   %p42 = (2, 56);
//   %wire_52 = &"VDD" @WIRE(mode="straight") {#"I3":4 %p42};
//   %p43 = (2, 75);
//   %wire_53 = &"VDD" @WIRE(mode="straight") {#"I2":4 %p43};
//   %p44 = (-11, 14);
//   %wire_54 = &"VDD" @WIRE(mode="straight") {#"I7":4 %p44};
//   %p45 = (2, -36);
//   %wire_55 = &"VDD" @WIRE(mode="straight") {#"I12":4 %p45};
//   %p46 = (-22, 76);
//   %wire_56 = &"VDD" @WIRE(mode="straight") {#"I0":4 %p46};
//   %p47 = (2, -17);
//   %wire_57 = &"VDD" @WIRE(mode="straight") {#"I10":4 %p47};
//   %p48 = (74, 36);
//   %wire_58 = &"VDD" @WIRE(mode="straight") {#"I15":4 %p48};
//   %p49 = (43, 74);
//   %wire_59 = &"VDD" @WIRE(mode="straight") {#"I39":3 %p49};
//   %wire_59 @TEXT("VDD", size=1, halign="middle", valign="baseline", rotate=90) => @PLACE(42.3, 74);
//   %wire_48 @TEXT("VDD", size=1, halign="middle", valign="baseline", rotate=90) => @PLACE(-22.7, -37);
//   %wire_58 @TEXT("VDD", size=1, halign="start", valign="baseline", rotate=90) => @PLACE(73.3, 32.4);
//   %wire_56 @TEXT("VDD", size=1, halign="middle", valign="baseline", rotate=90) => @PLACE(-22.7, 76);
//   %wire_57 @TEXT("VDD", size=1, halign="middle", valign="baseline", rotate=90) => @PLACE(1.3, -17);
//   %wire_55 @TEXT("VDD", size=1, halign="middle", valign="baseline", rotate=90) => @PLACE(1.3, -36);
//   %wire_54 @TEXT("VDD", size=1, halign="middle", valign="baseline", rotate=90) => @PLACE(-11.7, 13);
//   %wire_53 @TEXT("VDD", size=1, halign="middle", valign="baseline", rotate=90) => @PLACE(1.3, 75);
//   %wire_52 @TEXT("VDD", size=1, halign="middle", valign="baseline", rotate=90) => @PLACE(1.3, 56);
//   %wire_51 @TEXT("VDD", size=1, halign="middle", valign="baseline", rotate=90) => @PLACE(12.3, 27);
//   %wire_50 @TEXT("VDD", size=1, halign="middle", valign="baseline", rotate=90) => @PLACE(11.3, 44);
//   %wire_49 @TEXT("VDD", size=1, halign="middle", valign="baseline", rotate=90) => @PLACE(42.3, -35);
//   %wire_47 @TEXT("VDD", size=1, halign="middle", valign="baseline", rotate=90) => @PLACE(20.3, 12);
//   %wire_60 = &"RDY" @WIRE(mode="straight") {%port_9:p #"I4":1};
//   %wire_61 = &"R" @WIRE(mode="straight") {#"I0":3 #"I2":1};
//   %wire_61 @TEXT("R", size=1, halign="middle", valign="baseline") => @PLACE(-10, 70.7);
//   %p50 = (-29, -30);
//   %wire_62 = &"EN_SELF" @WIRE(mode="straight") {%p50 #"I13":2};
//   %p51 = (-29, 7);
//   %wire_63 = &"EN_SELF" @WIRE(mode="straight") {%p51 #"I7":3};
//   %p52 = (-29, 69);
//   %wire_64 = &"EN_SELF" @WIRE(mode="straight") {%p52 #"I0":2};
//   %wire_65 = &"EN_SELF" @WIRE(mode="straight") {%p50 %p51};
//   %wire_66 = &"EN_SELF" @WIRE(mode="straight") {%p51 %p52};
//   %wire_66 @TEXT("EN\_SELF", size=1, halign="middle", valign="baseline", rotate=90) => @PLACE(-29.7, 10);
//   %p53 = (2, 6);
//   %p54 = (2, 20);
//   %wire_67 = &"EN" @WIRE(mode="straight") {%p53 %p54};
//   %wire_68 = &"EN" @WIRE(mode="straight") {#"I7":2 %p53};
//   %wire_69 = &"EN" @WIRE(mode="straight") {%p54 #"I5":2};
//   %wire_70 = &"EN" @WIRE(mode="straight") {%p53 #"I6":3};
//   %wire_68 @TEXT("EN", size=1, halign="middle", valign="baseline") => @PLACE(-1, 6.7);
//   %wire_71 = &"COMPP" @WIRE(mode="straight") {%port_6:p #"I13":1};
//   %wire_71 @TEXT("COMPP", size=1, halign="middle", valign="top") => @PLACE(-32, -32.7);
//   %p55 = (66, 29);
//   %wire_72 = &"DOP" @WIRE(mode="straight") {%p55 #"I15":1};
//   %p56 = (50, 69);
//   %wire_73 = &"DOP" @WIRE(mode="straight") {#"I39":2 %port_5:p %p56};
//   %wire_72 @TEXT("DOP", size=1, halign="end", valign="baseline") => @PLACE(69.6, 29.7);
//   %p57 = (-36, 51);
//   %wire_74 = &"RST" @WIRE(mode="straight") {%p57 %port_4:p #"I3":1};
//   %p58 = (-37, -12);
//   %wire_75 = &"RST" @WIRE(mode="straight") {%p58 #"I10":1};
//   %wire_75 @TEXT("RST", size=1, halign="middle", valign="baseline") => @PLACE(-35, -11.3);
//   %p59 = (25, 21);
//   %wire_76 = &"NEXTB" @WIRE(mode="straight") {#"I5":3 %p59};
//   %p60 = (5, 29);
//   %p61 = (25, 29);
//   %wire_77 = &"NEXTB" @WIRE(mode="straight") {%p60 %p61};
//   %p62 = (5, 37);
//   %wire_78 = &"NEXTB" @WIRE(mode="straight") {%p62 #"I4":2};
//   %wire_79 = &"NEXTB" @WIRE(mode="straight") {%p60 %p62};
//   %wire_80 = &"NEXTB" @WIRE(mode="straight") {%p59 %p61};
//   %wire_81 = &"NEXTB" @WIRE(mode="straight") {%p59 %port_3:p};
//   %wire_81 @TEXT("NEXTB", size=1, halign="middle", valign="baseline") => @PLACE(46, 21.7);
//   %p63 = (-3, 8);
//   %p64 = (-3, 19);
//   %wire_82 = &"ENB" @WIRE(mode="straight") {%p63 %p64};
//   %wire_83 = &"ENB" @WIRE(mode="straight") {#"I7":1 %p63};
//   %wire_84 = &"ENB" @WIRE(mode="straight") {%port_2:p %p64};
//   %wire_84 @TEXT("ENB", size=1, halign="middle", valign="baseline") => @PLACE(-32, 19.7);
//   %p65 = (50, -30);
//   %wire_85 = &"DON" @WIRE(mode="straight") {#"I11":2 %port_1:p %p65};
//   %wire_86 = &"COMPN" @WIRE(mode="straight") {%port_0:p #"I0":1};
//   %wire_86 @TEXT("COMPN", size=1, halign="middle", valign="baseline") => @PLACE(-32, 71.7);
//   $JUNCTION @ATTACH %p7;
//   $JUNCTION @ATTACH %p16;
//   $JUNCTION @ATTACH %p51;
//   $JUNCTION @ATTACH %p53;
//   $JUNCTION @ATTACH %p59
// }
ends RS9_L6_SR_latch_1
