// RNL cell 2026_PIPETISAR_RESEARCH/RS9_L7_9bit_CDAC
// @RNL(type="header") {
//   @VERSION("0.3");
//   @USE-PACKAGE(name="rnl-std-spectre", version="0.3", path="rnl-std-spectre.rnl");
//   @USE-PACKAGE(name="eda-symbol", version="0.1", path="eda-symbol.rnl");
//   @USE-PACKAGE(name="eda-style", version="0.1", path="eda-style.rnl")
// }
subckt RS9_L7_9bit_CDAC BOT_9 BOT_8 BOT_7 BOT_6 BOT_5 BOT_4 BOT_3 BOT_2 \
        BOT_1 BOT_0 TOP VSS
    I21_1 (BOT_9 TOP) RS9_L8_9bit_CDAC_UNIT
    I21_2 (BOT_9 TOP) RS9_L8_9bit_CDAC_UNIT
    I21_3 (BOT_9 TOP) RS9_L8_9bit_CDAC_UNIT
    I21_4 (BOT_9 TOP) RS9_L8_9bit_CDAC_UNIT
    I21_5 (BOT_9 TOP) RS9_L8_9bit_CDAC_UNIT
    I21_6 (BOT_9 TOP) RS9_L8_9bit_CDAC_UNIT
    I21_7 (BOT_9 TOP) RS9_L8_9bit_CDAC_UNIT
    I21_8 (BOT_9 TOP) RS9_L8_9bit_CDAC_UNIT
    I21_9 (BOT_9 TOP) RS9_L8_9bit_CDAC_UNIT
    I21_10 (BOT_9 TOP) RS9_L8_9bit_CDAC_UNIT
    I21_11 (BOT_9 TOP) RS9_L8_9bit_CDAC_UNIT
    I21_12 (BOT_9 TOP) RS9_L8_9bit_CDAC_UNIT
    I21_13 (BOT_9 TOP) RS9_L8_9bit_CDAC_UNIT
    I21_14 (BOT_9 TOP) RS9_L8_9bit_CDAC_UNIT
    I21_15 (BOT_9 TOP) RS9_L8_9bit_CDAC_UNIT
    I21_16 (BOT_9 TOP) RS9_L8_9bit_CDAC_UNIT
    I21_17 (BOT_9 TOP) RS9_L8_9bit_CDAC_UNIT
    I21_18 (BOT_9 TOP) RS9_L8_9bit_CDAC_UNIT
    I21_19 (BOT_9 TOP) RS9_L8_9bit_CDAC_UNIT
    I21_20 (BOT_9 TOP) RS9_L8_9bit_CDAC_UNIT
    I21_21 (BOT_9 TOP) RS9_L8_9bit_CDAC_UNIT
    I21_22 (BOT_9 TOP) RS9_L8_9bit_CDAC_UNIT
    I21_23 (BOT_9 TOP) RS9_L8_9bit_CDAC_UNIT
    I21_24 (BOT_9 TOP) RS9_L8_9bit_CDAC_UNIT
    I21_25 (BOT_9 TOP) RS9_L8_9bit_CDAC_UNIT
    I21_26 (BOT_9 TOP) RS9_L8_9bit_CDAC_UNIT
    I21_27 (BOT_9 TOP) RS9_L8_9bit_CDAC_UNIT
    I21_28 (BOT_9 TOP) RS9_L8_9bit_CDAC_UNIT
    I21_29 (BOT_9 TOP) RS9_L8_9bit_CDAC_UNIT
    I21_30 (BOT_9 TOP) RS9_L8_9bit_CDAC_UNIT
    I21_31 (BOT_9 TOP) RS9_L8_9bit_CDAC_UNIT
    I21_32 (BOT_9 TOP) RS9_L8_9bit_CDAC_UNIT
    I21_33 (BOT_9 TOP) RS9_L8_9bit_CDAC_UNIT
    I21_34 (BOT_9 TOP) RS9_L8_9bit_CDAC_UNIT
    I21_35 (BOT_9 TOP) RS9_L8_9bit_CDAC_UNIT
    I21_36 (BOT_9 TOP) RS9_L8_9bit_CDAC_UNIT
    I21_37 (BOT_9 TOP) RS9_L8_9bit_CDAC_UNIT
    I21_38 (BOT_9 TOP) RS9_L8_9bit_CDAC_UNIT
    I21_39 (BOT_9 TOP) RS9_L8_9bit_CDAC_UNIT
    I21_40 (BOT_9 TOP) RS9_L8_9bit_CDAC_UNIT
    I21_41 (BOT_9 TOP) RS9_L8_9bit_CDAC_UNIT
    I21_42 (BOT_9 TOP) RS9_L8_9bit_CDAC_UNIT
    I21_43 (BOT_9 TOP) RS9_L8_9bit_CDAC_UNIT
    I21_44 (BOT_9 TOP) RS9_L8_9bit_CDAC_UNIT
    I21_45 (BOT_9 TOP) RS9_L8_9bit_CDAC_UNIT
    I21_46 (BOT_9 TOP) RS9_L8_9bit_CDAC_UNIT
    I21_47 (BOT_9 TOP) RS9_L8_9bit_CDAC_UNIT
    I21_48 (BOT_9 TOP) RS9_L8_9bit_CDAC_UNIT
    I21_49 (BOT_9 TOP) RS9_L8_9bit_CDAC_UNIT
    I21_50 (BOT_9 TOP) RS9_L8_9bit_CDAC_UNIT
    I21_51 (BOT_9 TOP) RS9_L8_9bit_CDAC_UNIT
    I21_52 (BOT_9 TOP) RS9_L8_9bit_CDAC_UNIT
    I21_53 (BOT_9 TOP) RS9_L8_9bit_CDAC_UNIT
    I21_54 (BOT_9 TOP) RS9_L8_9bit_CDAC_UNIT
    I21_55 (BOT_9 TOP) RS9_L8_9bit_CDAC_UNIT
    I21_56 (BOT_9 TOP) RS9_L8_9bit_CDAC_UNIT
    I21_57 (BOT_9 TOP) RS9_L8_9bit_CDAC_UNIT
    I21_58 (BOT_9 TOP) RS9_L8_9bit_CDAC_UNIT
    I21_59 (BOT_9 TOP) RS9_L8_9bit_CDAC_UNIT
    I21_60 (BOT_9 TOP) RS9_L8_9bit_CDAC_UNIT
    I21_61 (BOT_9 TOP) RS9_L8_9bit_CDAC_UNIT
    I21_62 (BOT_9 TOP) RS9_L8_9bit_CDAC_UNIT
    I21_63 (BOT_9 TOP) RS9_L8_9bit_CDAC_UNIT
    I21_64 (BOT_9 TOP) RS9_L8_9bit_CDAC_UNIT
    I21_65 (BOT_9 TOP) RS9_L8_9bit_CDAC_UNIT
    I21_66 (BOT_9 TOP) RS9_L8_9bit_CDAC_UNIT
    I21_67 (BOT_9 TOP) RS9_L8_9bit_CDAC_UNIT
    I21_68 (BOT_9 TOP) RS9_L8_9bit_CDAC_UNIT
    I21_69 (BOT_9 TOP) RS9_L8_9bit_CDAC_UNIT
    I21_70 (BOT_9 TOP) RS9_L8_9bit_CDAC_UNIT
    I21_71 (BOT_9 TOP) RS9_L8_9bit_CDAC_UNIT
    I21_72 (BOT_9 TOP) RS9_L8_9bit_CDAC_UNIT
    I21_73 (BOT_9 TOP) RS9_L8_9bit_CDAC_UNIT
    I21_74 (BOT_9 TOP) RS9_L8_9bit_CDAC_UNIT
    I21_75 (BOT_9 TOP) RS9_L8_9bit_CDAC_UNIT
    I21_76 (BOT_9 TOP) RS9_L8_9bit_CDAC_UNIT
    I21_77 (BOT_9 TOP) RS9_L8_9bit_CDAC_UNIT
    I21_78 (BOT_9 TOP) RS9_L8_9bit_CDAC_UNIT
    I21_79 (BOT_9 TOP) RS9_L8_9bit_CDAC_UNIT
    I21_80 (BOT_9 TOP) RS9_L8_9bit_CDAC_UNIT
    I21_81 (BOT_9 TOP) RS9_L8_9bit_CDAC_UNIT
    I21_82 (BOT_9 TOP) RS9_L8_9bit_CDAC_UNIT
    I21_83 (BOT_9 TOP) RS9_L8_9bit_CDAC_UNIT
    I21_84 (BOT_9 TOP) RS9_L8_9bit_CDAC_UNIT
    I21_85 (BOT_9 TOP) RS9_L8_9bit_CDAC_UNIT
    I21_86 (BOT_9 TOP) RS9_L8_9bit_CDAC_UNIT
    I21_87 (BOT_9 TOP) RS9_L8_9bit_CDAC_UNIT
    I21_88 (BOT_9 TOP) RS9_L8_9bit_CDAC_UNIT
    I21_89 (BOT_9 TOP) RS9_L8_9bit_CDAC_UNIT
    I21_90 (BOT_9 TOP) RS9_L8_9bit_CDAC_UNIT
    I21_91 (BOT_9 TOP) RS9_L8_9bit_CDAC_UNIT
    I21_92 (BOT_9 TOP) RS9_L8_9bit_CDAC_UNIT
    I21_93 (BOT_9 TOP) RS9_L8_9bit_CDAC_UNIT
    I21_94 (BOT_9 TOP) RS9_L8_9bit_CDAC_UNIT
    I21_95 (BOT_9 TOP) RS9_L8_9bit_CDAC_UNIT
    I21_96 (BOT_9 TOP) RS9_L8_9bit_CDAC_UNIT
    I21_97 (BOT_9 TOP) RS9_L8_9bit_CDAC_UNIT
    I21_98 (BOT_9 TOP) RS9_L8_9bit_CDAC_UNIT
    I21_99 (BOT_9 TOP) RS9_L8_9bit_CDAC_UNIT
    I21_100 (BOT_9 TOP) RS9_L8_9bit_CDAC_UNIT
    I21_101 (BOT_9 TOP) RS9_L8_9bit_CDAC_UNIT
    I21_102 (BOT_9 TOP) RS9_L8_9bit_CDAC_UNIT
    I21_103 (BOT_9 TOP) RS9_L8_9bit_CDAC_UNIT
    I21_104 (BOT_9 TOP) RS9_L8_9bit_CDAC_UNIT
    I21_105 (BOT_9 TOP) RS9_L8_9bit_CDAC_UNIT
    I21_106 (BOT_9 TOP) RS9_L8_9bit_CDAC_UNIT
    I21_107 (BOT_9 TOP) RS9_L8_9bit_CDAC_UNIT
    I21_108 (BOT_9 TOP) RS9_L8_9bit_CDAC_UNIT
    I20_1 (BOT_8 TOP) RS9_L8_9bit_CDAC_UNIT
    I20_2 (BOT_8 TOP) RS9_L8_9bit_CDAC_UNIT
    I20_3 (BOT_8 TOP) RS9_L8_9bit_CDAC_UNIT
    I20_4 (BOT_8 TOP) RS9_L8_9bit_CDAC_UNIT
    I20_5 (BOT_8 TOP) RS9_L8_9bit_CDAC_UNIT
    I20_6 (BOT_8 TOP) RS9_L8_9bit_CDAC_UNIT
    I20_7 (BOT_8 TOP) RS9_L8_9bit_CDAC_UNIT
    I20_8 (BOT_8 TOP) RS9_L8_9bit_CDAC_UNIT
    I20_9 (BOT_8 TOP) RS9_L8_9bit_CDAC_UNIT
    I20_10 (BOT_8 TOP) RS9_L8_9bit_CDAC_UNIT
    I20_11 (BOT_8 TOP) RS9_L8_9bit_CDAC_UNIT
    I20_12 (BOT_8 TOP) RS9_L8_9bit_CDAC_UNIT
    I20_13 (BOT_8 TOP) RS9_L8_9bit_CDAC_UNIT
    I20_14 (BOT_8 TOP) RS9_L8_9bit_CDAC_UNIT
    I20_15 (BOT_8 TOP) RS9_L8_9bit_CDAC_UNIT
    I20_16 (BOT_8 TOP) RS9_L8_9bit_CDAC_UNIT
    I20_17 (BOT_8 TOP) RS9_L8_9bit_CDAC_UNIT
    I20_18 (BOT_8 TOP) RS9_L8_9bit_CDAC_UNIT
    I20_19 (BOT_8 TOP) RS9_L8_9bit_CDAC_UNIT
    I20_20 (BOT_8 TOP) RS9_L8_9bit_CDAC_UNIT
    I20_21 (BOT_8 TOP) RS9_L8_9bit_CDAC_UNIT
    I20_22 (BOT_8 TOP) RS9_L8_9bit_CDAC_UNIT
    I20_23 (BOT_8 TOP) RS9_L8_9bit_CDAC_UNIT
    I20_24 (BOT_8 TOP) RS9_L8_9bit_CDAC_UNIT
    I20_25 (BOT_8 TOP) RS9_L8_9bit_CDAC_UNIT
    I20_26 (BOT_8 TOP) RS9_L8_9bit_CDAC_UNIT
    I20_27 (BOT_8 TOP) RS9_L8_9bit_CDAC_UNIT
    I20_28 (BOT_8 TOP) RS9_L8_9bit_CDAC_UNIT
    I20_29 (BOT_8 TOP) RS9_L8_9bit_CDAC_UNIT
    I20_30 (BOT_8 TOP) RS9_L8_9bit_CDAC_UNIT
    I20_31 (BOT_8 TOP) RS9_L8_9bit_CDAC_UNIT
    I20_32 (BOT_8 TOP) RS9_L8_9bit_CDAC_UNIT
    I20_33 (BOT_8 TOP) RS9_L8_9bit_CDAC_UNIT
    I20_34 (BOT_8 TOP) RS9_L8_9bit_CDAC_UNIT
    I20_35 (BOT_8 TOP) RS9_L8_9bit_CDAC_UNIT
    I20_36 (BOT_8 TOP) RS9_L8_9bit_CDAC_UNIT
    I20_37 (BOT_8 TOP) RS9_L8_9bit_CDAC_UNIT
    I20_38 (BOT_8 TOP) RS9_L8_9bit_CDAC_UNIT
    I20_39 (BOT_8 TOP) RS9_L8_9bit_CDAC_UNIT
    I20_40 (BOT_8 TOP) RS9_L8_9bit_CDAC_UNIT
    I20_41 (BOT_8 TOP) RS9_L8_9bit_CDAC_UNIT
    I20_42 (BOT_8 TOP) RS9_L8_9bit_CDAC_UNIT
    I20_43 (BOT_8 TOP) RS9_L8_9bit_CDAC_UNIT
    I20_44 (BOT_8 TOP) RS9_L8_9bit_CDAC_UNIT
    I20_45 (BOT_8 TOP) RS9_L8_9bit_CDAC_UNIT
    I20_46 (BOT_8 TOP) RS9_L8_9bit_CDAC_UNIT
    I20_47 (BOT_8 TOP) RS9_L8_9bit_CDAC_UNIT
    I20_48 (BOT_8 TOP) RS9_L8_9bit_CDAC_UNIT
    I20_49 (BOT_8 TOP) RS9_L8_9bit_CDAC_UNIT
    I20_50 (BOT_8 TOP) RS9_L8_9bit_CDAC_UNIT
    I20_51 (BOT_8 TOP) RS9_L8_9bit_CDAC_UNIT
    I20_52 (BOT_8 TOP) RS9_L8_9bit_CDAC_UNIT
    I20_53 (BOT_8 TOP) RS9_L8_9bit_CDAC_UNIT
    I20_54 (BOT_8 TOP) RS9_L8_9bit_CDAC_UNIT
    I20_55 (BOT_8 TOP) RS9_L8_9bit_CDAC_UNIT
    I20_56 (BOT_8 TOP) RS9_L8_9bit_CDAC_UNIT
    I20_57 (BOT_8 TOP) RS9_L8_9bit_CDAC_UNIT
    I20_58 (BOT_8 TOP) RS9_L8_9bit_CDAC_UNIT
    I20_59 (BOT_8 TOP) RS9_L8_9bit_CDAC_UNIT
    I20_60 (BOT_8 TOP) RS9_L8_9bit_CDAC_UNIT
    I20_61 (BOT_8 TOP) RS9_L8_9bit_CDAC_UNIT
    I20_62 (BOT_8 TOP) RS9_L8_9bit_CDAC_UNIT
    I20_63 (BOT_8 TOP) RS9_L8_9bit_CDAC_UNIT
    I20_64 (BOT_8 TOP) RS9_L8_9bit_CDAC_UNIT
    I20_65 (BOT_8 TOP) RS9_L8_9bit_CDAC_UNIT
    I20_66 (BOT_8 TOP) RS9_L8_9bit_CDAC_UNIT
    I20_67 (BOT_8 TOP) RS9_L8_9bit_CDAC_UNIT
    I20_68 (BOT_8 TOP) RS9_L8_9bit_CDAC_UNIT
    I20_69 (BOT_8 TOP) RS9_L8_9bit_CDAC_UNIT
    I20_70 (BOT_8 TOP) RS9_L8_9bit_CDAC_UNIT
    I19_1 (BOT_7 TOP) RS9_L8_9bit_CDAC_UNIT
    I19_2 (BOT_7 TOP) RS9_L8_9bit_CDAC_UNIT
    I19_3 (BOT_7 TOP) RS9_L8_9bit_CDAC_UNIT
    I19_4 (BOT_7 TOP) RS9_L8_9bit_CDAC_UNIT
    I19_5 (BOT_7 TOP) RS9_L8_9bit_CDAC_UNIT
    I19_6 (BOT_7 TOP) RS9_L8_9bit_CDAC_UNIT
    I19_7 (BOT_7 TOP) RS9_L8_9bit_CDAC_UNIT
    I19_8 (BOT_7 TOP) RS9_L8_9bit_CDAC_UNIT
    I19_9 (BOT_7 TOP) RS9_L8_9bit_CDAC_UNIT
    I19_10 (BOT_7 TOP) RS9_L8_9bit_CDAC_UNIT
    I19_11 (BOT_7 TOP) RS9_L8_9bit_CDAC_UNIT
    I19_12 (BOT_7 TOP) RS9_L8_9bit_CDAC_UNIT
    I19_13 (BOT_7 TOP) RS9_L8_9bit_CDAC_UNIT
    I19_14 (BOT_7 TOP) RS9_L8_9bit_CDAC_UNIT
    I19_15 (BOT_7 TOP) RS9_L8_9bit_CDAC_UNIT
    I19_16 (BOT_7 TOP) RS9_L8_9bit_CDAC_UNIT
    I19_17 (BOT_7 TOP) RS9_L8_9bit_CDAC_UNIT
    I19_18 (BOT_7 TOP) RS9_L8_9bit_CDAC_UNIT
    I19_19 (BOT_7 TOP) RS9_L8_9bit_CDAC_UNIT
    I19_20 (BOT_7 TOP) RS9_L8_9bit_CDAC_UNIT
    I19_21 (BOT_7 TOP) RS9_L8_9bit_CDAC_UNIT
    I19_22 (BOT_7 TOP) RS9_L8_9bit_CDAC_UNIT
    I19_23 (BOT_7 TOP) RS9_L8_9bit_CDAC_UNIT
    I19_24 (BOT_7 TOP) RS9_L8_9bit_CDAC_UNIT
    I19_25 (BOT_7 TOP) RS9_L8_9bit_CDAC_UNIT
    I19_26 (BOT_7 TOP) RS9_L8_9bit_CDAC_UNIT
    I19_27 (BOT_7 TOP) RS9_L8_9bit_CDAC_UNIT
    I19_28 (BOT_7 TOP) RS9_L8_9bit_CDAC_UNIT
    I19_29 (BOT_7 TOP) RS9_L8_9bit_CDAC_UNIT
    I19_30 (BOT_7 TOP) RS9_L8_9bit_CDAC_UNIT
    I19_31 (BOT_7 TOP) RS9_L8_9bit_CDAC_UNIT
    I19_32 (BOT_7 TOP) RS9_L8_9bit_CDAC_UNIT
    I19_33 (BOT_7 TOP) RS9_L8_9bit_CDAC_UNIT
    I19_34 (BOT_7 TOP) RS9_L8_9bit_CDAC_UNIT
    I19_35 (BOT_7 TOP) RS9_L8_9bit_CDAC_UNIT
    I19_36 (BOT_7 TOP) RS9_L8_9bit_CDAC_UNIT
    I18_1 (BOT_6 TOP) RS9_L8_9bit_CDAC_UNIT
    I18_2 (BOT_6 TOP) RS9_L8_9bit_CDAC_UNIT
    I18_3 (BOT_6 TOP) RS9_L8_9bit_CDAC_UNIT
    I18_4 (BOT_6 TOP) RS9_L8_9bit_CDAC_UNIT
    I18_5 (BOT_6 TOP) RS9_L8_9bit_CDAC_UNIT
    I18_6 (BOT_6 TOP) RS9_L8_9bit_CDAC_UNIT
    I18_7 (BOT_6 TOP) RS9_L8_9bit_CDAC_UNIT
    I18_8 (BOT_6 TOP) RS9_L8_9bit_CDAC_UNIT
    I18_9 (BOT_6 TOP) RS9_L8_9bit_CDAC_UNIT
    I18_10 (BOT_6 TOP) RS9_L8_9bit_CDAC_UNIT
    I18_11 (BOT_6 TOP) RS9_L8_9bit_CDAC_UNIT
    I18_12 (BOT_6 TOP) RS9_L8_9bit_CDAC_UNIT
    I18_13 (BOT_6 TOP) RS9_L8_9bit_CDAC_UNIT
    I18_14 (BOT_6 TOP) RS9_L8_9bit_CDAC_UNIT
    I18_15 (BOT_6 TOP) RS9_L8_9bit_CDAC_UNIT
    I18_16 (BOT_6 TOP) RS9_L8_9bit_CDAC_UNIT
    I18_17 (BOT_6 TOP) RS9_L8_9bit_CDAC_UNIT
    I18_18 (BOT_6 TOP) RS9_L8_9bit_CDAC_UNIT
    I18_19 (BOT_6 TOP) RS9_L8_9bit_CDAC_UNIT
    I17_1 (BOT_5 TOP) RS9_L8_9bit_CDAC_UNIT
    I17_2 (BOT_5 TOP) RS9_L8_9bit_CDAC_UNIT
    I17_3 (BOT_5 TOP) RS9_L8_9bit_CDAC_UNIT
    I17_4 (BOT_5 TOP) RS9_L8_9bit_CDAC_UNIT
    I17_5 (BOT_5 TOP) RS9_L8_9bit_CDAC_UNIT
    I17_6 (BOT_5 TOP) RS9_L8_9bit_CDAC_UNIT
    I17_7 (BOT_5 TOP) RS9_L8_9bit_CDAC_UNIT
    I17_8 (BOT_5 TOP) RS9_L8_9bit_CDAC_UNIT
    I17_9 (BOT_5 TOP) RS9_L8_9bit_CDAC_UNIT
    I17_10 (BOT_5 TOP) RS9_L8_9bit_CDAC_UNIT
    I16_1 (BOT_4 TOP) RS9_L8_9bit_CDAC_UNIT
    I16_2 (BOT_4 TOP) RS9_L8_9bit_CDAC_UNIT
    I16_3 (BOT_4 TOP) RS9_L8_9bit_CDAC_UNIT
    I16_4 (BOT_4 TOP) RS9_L8_9bit_CDAC_UNIT
    I16_5 (BOT_4 TOP) RS9_L8_9bit_CDAC_UNIT
    I16_6 (BOT_4 TOP) RS9_L8_9bit_CDAC_UNIT
    I15_1 (BOT_3 TOP) RS9_L8_9bit_CDAC_UNIT
    I15_2 (BOT_3 TOP) RS9_L8_9bit_CDAC_UNIT
    I15_3 (BOT_3 TOP) RS9_L8_9bit_CDAC_UNIT
    I12 (BOT_0 TOP) RS9_L8_9bit_CDAC_UNIT
    I14_1 (BOT_2 TOP) RS9_L8_9bit_CDAC_UNIT
    I14_2 (BOT_2 TOP) RS9_L8_9bit_CDAC_UNIT
    I13 (BOT_1 TOP) RS9_L8_9bit_CDAC_UNIT
// @RNL(author="rnl-virtuoso") {
//   %block_symbol = @DEFINE-SYMBOL(box=[0, -5, 33, 5]) {
//     @LINE {(0, 0) (4, 0)};
//     @LINE {(33, 0) (29, 0)};
//     @LINE {(16, -9) (16, -5)};
//     @RECTANGLE {(4, -5) (29, 5)};
//     ? @TEXT("${name}", size=1, halign="start", valign="middle", key="name") => @PLACE(29, 5);
//     ? @TEXT("${model}", size=1, halign="middle", valign="middle", key="model") => @PLACE(16.5, 0);
//     (0, 0) @PIN(terminal=["BOT_9", "BOT_8", "BOT_7", "BOT_6", "BOT_5", "BOT_4", "BOT_3", "BOT_2", "BOT_1", "BOT_0"]);
//     (4.6, 0) @TEXT("BOT<9:0>", size=1, halign="start", valign="middle");
//     (16, -9) @PIN(terminal="VSS");
//     (16, -4.4) @TEXT("VSS", size=1, halign="start", valign="middle", rotate=90);
//     (33, 0) @PIN(terminal="TOP");
//     (28.4, 0) @TEXT("TOP", size=1, halign="end", valign="middle")
//   };
//   # @SET-SYMBOL %block_symbol;
//   %bundle_0 = {#"I15_1" #"I15_2" #"I15_3"} @BUNDLE;
//   %bundle_0 @PLACE(-18, 2) => @ORIENT("R180");
//   %bundle_0 @TEXT("I15<1:3>", key="name");
//   %bundle_1 = {#"I20_1" #"I20_2" #"I20_3" #"I20_4" #"I20_5" #"I20_6" #"I20_7" #"I20_8" #"I20_9" #"I20_10" #"I20_11" #"I20_12" #"I20_13" #"I20_14" #"I20_15" #"I20_16" #"I20_17" #"I20_18" #"I20_19" #"I20_20" #"I20_21" #"I20_22" #"I20_23" #"I20_24" #"I20_25" #"I20_26" #"I20_27" #"I20_28" #"I20_29" #"I20_30" #"I20_31" #"I20_32" #"I20_33" #"I20_34" #"I20_35" #"I20_36" #"I20_37" #"I20_38" #"I20_39" #"I20_40" #"I20_41" #"I20_42" #"I20_43" #"I20_44" #"I20_45" #"I20_46" #"I20_47" #"I20_48" #"I20_49" #"I20_50" #"I20_51" #"I20_52" #"I20_53" #"I20_54" #"I20_55" #"I20_56" #"I20_57" #"I20_58" #"I20_59" #"I20_60" #"I20_61" #"I20_62" #"I20_63" #"I20_64" #"I20_65" #"I20_66" #"I20_67" #"I20_68" #"I20_69" #"I20_70"} @BUNDLE;
//   %bundle_1 @PLACE(50, 2) => @ORIENT("R180");
//   %bundle_1 @TEXT("I20<1:70>", key="name");
//   #"I12" @PLACE(-58, 2) => @ORIENT("R180");
//   %bundle_2 = {#"I14_1" #"I14_2"} @BUNDLE;
//   %bundle_2 @PLACE(-31, 2) => @ORIENT("R180");
//   %bundle_2 @TEXT("I14<1:2>", key="name");
//   #"I13" @PLACE(-44, 2) => @ORIENT("R180");
//   %bundle_3 = {#"I19_1" #"I19_2" #"I19_3" #"I19_4" #"I19_5" #"I19_6" #"I19_7" #"I19_8" #"I19_9" #"I19_10" #"I19_11" #"I19_12" #"I19_13" #"I19_14" #"I19_15" #"I19_16" #"I19_17" #"I19_18" #"I19_19" #"I19_20" #"I19_21" #"I19_22" #"I19_23" #"I19_24" #"I19_25" #"I19_26" #"I19_27" #"I19_28" #"I19_29" #"I19_30" #"I19_31" #"I19_32" #"I19_33" #"I19_34" #"I19_35" #"I19_36"} @BUNDLE;
//   %bundle_3 @PLACE(36, 2) => @ORIENT("R180");
//   %bundle_3 @TEXT("I19<1:36>", key="name");
//   %bundle_4 = {#"I16_1" #"I16_2" #"I16_3" #"I16_4" #"I16_5" #"I16_6"} @BUNDLE;
//   %bundle_4 @PLACE(-4, 2) => @ORIENT("R180");
//   %bundle_4 @TEXT("I16<1:6>", key="name");
//   %bundle_5 = {#"I17_1" #"I17_2" #"I17_3" #"I17_4" #"I17_5" #"I17_6" #"I17_7" #"I17_8" #"I17_9" #"I17_10"} @BUNDLE;
//   %bundle_5 @PLACE(9, 2) => @ORIENT("R180");
//   %bundle_5 @TEXT("I17<1:10>", key="name");
//   %bundle_6 = {#"I21_1" #"I21_2" #"I21_3" #"I21_4" #"I21_5" #"I21_6" #"I21_7" #"I21_8" #"I21_9" #"I21_10" #"I21_11" #"I21_12" #"I21_13" #"I21_14" #"I21_15" #"I21_16" #"I21_17" #"I21_18" #"I21_19" #"I21_20" #"I21_21" #"I21_22" #"I21_23" #"I21_24" #"I21_25" #"I21_26" #"I21_27" #"I21_28" #"I21_29" #"I21_30" #"I21_31" #"I21_32" #"I21_33" #"I21_34" #"I21_35" #"I21_36" #"I21_37" #"I21_38" #"I21_39" #"I21_40" #"I21_41" #"I21_42" #"I21_43" #"I21_44" #"I21_45" #"I21_46" #"I21_47" #"I21_48" #"I21_49" #"I21_50" #"I21_51" #"I21_52" #"I21_53" #"I21_54" #"I21_55" #"I21_56" #"I21_57" #"I21_58" #"I21_59" #"I21_60" #"I21_61" #"I21_62" #"I21_63" #"I21_64" #"I21_65" #"I21_66" #"I21_67" #"I21_68" #"I21_69" #"I21_70" #"I21_71" #"I21_72" #"I21_73" #"I21_74" #"I21_75" #"I21_76" #"I21_77" #"I21_78" #"I21_79" #"I21_80" #"I21_81" #"I21_82" #"I21_83" #"I21_84" #"I21_85" #"I21_86" #"I21_87" #"I21_88" #"I21_89" #"I21_90" #"I21_91" #"I21_92" #"I21_93" #"I21_94" #"I21_95" #"I21_96" #"I21_97" #"I21_98" #"I21_99" #"I21_100" #"I21_101" #"I21_102" #"I21_103" #"I21_104" #"I21_105" #"I21_106" #"I21_107" #"I21_108"} @BUNDLE;
//   %bundle_6 @PLACE(63, 2) => @ORIENT("R180");
//   %bundle_6 @TEXT("I21<1:108>", key="name");
//   %bundle_7 = {#"I18_1" #"I18_2" #"I18_3" #"I18_4" #"I18_5" #"I18_6" #"I18_7" #"I18_8" #"I18_9" #"I18_10" #"I18_11" #"I18_12" #"I18_13" #"I18_14" #"I18_15" #"I18_16" #"I18_17" #"I18_18" #"I18_19"} @BUNDLE;
//   %bundle_7 @PLACE(22, 2) => @ORIENT("R180");
//   %bundle_7 @TEXT("I18<1:19>", key="name");
//   %marker_256 = (-71, 11);
//   $FIGURE @ATTACH %marker_256 => @SET-SYMBOL $NO_CONNECT_SYMBOL => @ORIENT("R90");
//   %input_port_symbol = @DEFINE-SYMBOL(box=[-2, -1, 0, 1]) {
//       @LINE(fill="linecolor", linestyle="none") {(-2, -0.9) (-2, 0.9) (-0.9, 0.9) (0, 0) (-0.9, -0.9) (-2, -0.9)};
//       (0, 0) @PIN(terminal=1, direction="right");
//       ? @TEXT("${name}", key="name", halign="middle") => @PLACE(-1, 1.6)
//     };
//   %bus_port_type_0 = @DEFINE(roles=[["p", "net"], ["p1", "net"], ["p2", "net"], ["p3", "net"], ["p4", "net"], ["p5", "net"], ["p6", "net"], ["p7", "net"], ["p8", "net"], ["p9", "net"]]) {};
//   %bus_port_type_0_symbol = @DEFINE-SYMBOL {(0, 0) @PIN(terminal=[1, 2, 3, 4, 5, 6, 7, 8, 9, 10])};
//   {&"BOT_9" &"BOT_8" &"BOT_7" &"BOT_6" &"BOT_5" &"BOT_4" &"BOT_3" &"BOT_2" &"BOT_1" &"BOT_0"} @REMOVE-FROM $PORT_FILL_SET;
//   %port_0 = %bus_port_type_0 @ATTACH &"BOT_9" &"BOT_8" &"BOT_7" &"BOT_6" &"BOT_5" &"BOT_4" &"BOT_3" &"BOT_2" &"BOT_1" &"BOT_0" => @PLACE(-73, 17) => @ORIENT("R0");
//   %port_0 @SET-SYMBOL %bus_port_type_0_symbol;
//   %port_0_marker = $IO_PORT @ATTACH &"BOT_9" => @PLACE(-73, 17) => @ORIENT("R0");
//   %port_0_marker @SET-SYMBOL %input_port_symbol;
//   %port_0_marker @TEXT("BOT<9:0>", key="name");
//   %port_1 = $IO_PORT @ATTACH &"VSS" => @PLACE(-74, 11) => @ORIENT("R0");
//   %output_port_symbol = @DEFINE-SYMBOL(box=[0, -1, 2, 1]) {
//       @LINE(fill="linecolor", linestyle="none") {(0, -0.9) (0, 0.9) (1.1, 0.9) (2, 0) (1.1, -0.9) (0, -0.9)};
//       (0, 0) @PIN(terminal=1, direction="left");
//       ? @TEXT("${name}", key="name", halign="middle") => @PLACE(1, 1.6)
//     };
//   %port_2 = $IO_PORT @ATTACH &"TOP" => @PLACE(-75, 14) => @ORIENT("R0");
//   %port_2 @SET-SYMBOL %output_port_symbol;
//   %port_2 @TEXT("TOP", key="name");
//   %p0 = (9, 15);
//   %p1 = (22, 15);
//   %wire_0 = &"TOP" @WIRE(mode="straight") {%p0 %p1};
//   %p2 = (63, 15);
//   %wire_1 = &"TOP" @WIRE(mode="straight") {%bundle_6:2 %p2};
//   %p3 = (50, 15);
//   %wire_2 = &"TOP" @WIRE(mode="straight") {%bundle_1:2 %p3};
//   %p4 = (-18, 15);
//   %wire_3 = &"TOP" @WIRE(mode="straight") {%bundle_0:2 %p4};
//   %p5 = (-4, 15);
//   %wire_4 = &"TOP" @WIRE(mode="straight") {%bundle_4:2 %p5};
//   %wire_5 = &"TOP" @WIRE(mode="straight") {%bundle_7:2 %p1};
//   %p6 = (-58, 15);
//   %p7 = (-44, 15);
//   %wire_6 = &"TOP" @WIRE(mode="straight") {%p6 %p7};
//   %wire_7 = &"TOP" @WIRE(mode="straight") {%bundle_5:2 %p0};
//   %wire_8 = &"TOP" @WIRE(mode="straight") {#"I12":2 %p6};
//   %wire_9 = &"TOP" @WIRE(mode="straight") {%p4 %p5};
//   %p8 = (-31, 15);
//   %wire_10 = &"TOP" @WIRE(mode="straight") {%p7 %p8};
//   %wire_11 = &"TOP" @WIRE(mode="straight") {#"I13":2 %p7};
//   %wire_12 = &"TOP" @WIRE(mode="straight") {%p5 %p0};
//   %wire_13 = &"TOP" @WIRE(mode="straight") {%p8 %p4};
//   %wire_14 = &"TOP" @WIRE(mode="straight") {%bundle_2:2 %p8};
//   %p9 = (36, 15);
//   %wire_15 = &"TOP" @WIRE(mode="straight") {%p1 %p9};
//   %wire_16 = &"TOP" @WIRE(mode="straight") {%bundle_3:2 %p9};
//   %wire_17 = &"TOP" @WIRE(mode="straight") {%p9 %p3};
//   %wire_18 = &"TOP" @WIRE(mode="straight") {%p3 %p2};
//   %wire_17 @TEXT("TOP", size=1, halign="middle", valign="baseline") => @PLACE(44, 15.7);
//   %p10 = (-4, -1);
//   %wire_19 = &"BOT_4" @WIRE(mode="straight") {%p10 %bundle_4:1};
//   %wire_19 @TEXT("BOT\_4", size=1, halign="middle", valign="baseline", rotate=90) => @PLACE(-4.7, 2);
//   %p11 = (-58, -1);
//   %wire_20 = &"BOT_0" @WIRE(mode="straight") {%p11 #"I12":1};
//   %wire_20 @TEXT("BOT\_0", size=1, halign="middle", valign="baseline", rotate=90) => @PLACE(-58.7, 1);
//   %p12 = (63, -1);
//   %wire_21 = &"BOT_9" @WIRE(mode="straight") {%p12 %bundle_6:1};
//   %wire_21 @TEXT("BOT\_9", size=1, halign="middle", valign="baseline", rotate=90) => @PLACE(62.3, 2);
//   %wire_22 = &"VSS" @WIRE(mode="straight") {%port_1:p %marker_256};
//   %p13 = (50, -1);
//   %wire_23 = &"BOT_8" @WIRE(mode="straight") {%p13 %bundle_1:1};
//   %wire_23 @TEXT("BOT\_8", size=1, halign="middle", valign="baseline", rotate=90) => @PLACE(49.3, 2);
//   %p14 = (36, -1);
//   %wire_24 = &"BOT_7" @WIRE(mode="straight") {%p14 %bundle_3:1};
//   %wire_24 @TEXT("BOT\_7", size=1, halign="middle", valign="baseline", rotate=90) => @PLACE(35.3, 2);
//   %p15 = (-18, -1);
//   %wire_25 = &"BOT_3" @WIRE(mode="straight") {%p15 %bundle_0:1};
//   %wire_25 @TEXT("BOT\_3", size=1, halign="middle", valign="baseline", rotate=90) => @PLACE(-18.7, 1);
//   %p16 = (-31, -1);
//   %wire_26 = &"BOT_2" @WIRE(mode="straight") {%p16 %bundle_2:1};
//   %wire_26 @TEXT("BOT\_2", size=1, halign="middle", valign="baseline", rotate=90) => @PLACE(-31.7, 2);
//   %p17 = (-44, -1);
//   %wire_27 = &"BOT_1" @WIRE(mode="straight") {%p17 #"I13":1};
//   %wire_27 @TEXT("BOT\_1", size=1, halign="middle", valign="baseline", rotate=90) => @PLACE(-44.7, 2);
//   %p18 = (22, -1);
//   %wire_28 = &"BOT_6" @WIRE(mode="straight") {%p18 %bundle_7:1};
//   %wire_28 @TEXT("BOT\_6", size=1, halign="middle", valign="baseline", rotate=90) => @PLACE(21.3, 2);
//   %p19 = (9, -1);
//   %wire_29 = &"BOT_5" @WIRE(mode="straight") {%p19 %bundle_5:1};
//   %wire_29 @TEXT("BOT\_5", size=1, halign="middle", valign="baseline", rotate=90) => @PLACE(8.3, 2);
//   $JUNCTION @ATTACH %p0;
//   $JUNCTION @ATTACH %p1;
//   $JUNCTION @ATTACH %p3;
//   $JUNCTION @ATTACH %p4;
//   $JUNCTION @ATTACH %p5;
//   $JUNCTION @ATTACH %p7;
//   $JUNCTION @ATTACH %p8;
//   $JUNCTION @ATTACH %p9;
//   (-60, 20) @TEXT("1           1          2        2+1       4+2       8+2    16+2+1      32+4     64+4+2   128-20", size=1.6, halign="start", valign="top")
// }
ends RS9_L7_9bit_CDAC
