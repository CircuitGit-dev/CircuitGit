// RNL cell 2026_PIPETISAR_RESEARCH/L4_stage1_flash_clkbooster
// @RNL(type="header") {
//   @VERSION("0.3");
//   @USE-PACKAGE(name="rnl-std-spectre", version="0.3", path="rnl-std-spectre.rnl");
//   @USE-PACKAGE(name="eda-symbol", version="0.1", path="eda-symbol.rnl");
//   @USE-PACKAGE(name="eda-style", version="0.1", path="eda-style.rnl")
// }
subckt L4_stage1_flash_clkbooster CLKN CLKNBUF CLKPBST CLKPBUF VDD VSS
    C0 (net3 net2) cfmom_2t nr=32 lr=5.2u w=50n s=50n stm=2 spm=7 multi=1
    M19 (CLKPBST VDD net2 VSS) nch_ulvt_mac l=30n w=4u multi=1 nf=8 \
        sd=100n ad=2e-13 as=2.25e-13 pd=4.8u ps=5.9u nrd=0.135370 \
        nrs=0.135370 sa=295.835n sb=295.835n sa1=149.315n sa2=274.565n \
        sa3=507.343n sa4=281.096n sb1=149.315n sb2=274.565n sb3=507.343n \
        spa=100n spa1=100n spa2=100n spa3=100n sap=142.36n sapb=158.808n \
        spba=115.715n spba1=117.043n dfm_flag=0 spmt=1.11111e+15 spomt=0 \
        spomt1=1.11111e+60 spmb=1.11111e+15 spomb=0 spomb1=1.11111e+60
    M15 (net2 CLKN VSS VSS) nch_ulvt_mac l=30n w=4u multi=1 nf=4 sd=100n \
        ad=2e-13 as=2.5e-13 pd=4.4u ps=6.5u nrd=0.108289 nrs=0.108289 \
        sa=179.203n sb=179.203n sa1=118.069n sa2=174.76n sa3=310.76n \
        sa4=171.966n sb1=118.069n sb2=174.76n sb3=310.76n spa=100n \
        spa1=100n spa2=100n spa3=100n sap=120.952n sapb=140.537n \
        spba=115.715n spba1=117.043n dfm_flag=0 spmt=1.11111e+15 spomt=0 \
        spomt1=1.11111e+60 spmb=1.11111e+15 spomb=0 spomb1=1.11111e+60
    M24 (net1 net2 VSS VSS) nch_ulvt_mac l=30n w=1u multi=1 nf=1 sd=100n \
        ad=7.5e-14 as=7.5e-14 pd=2.15u ps=2.15u nrd=0.289519 nrs=0.289519 \
        sa=75.0n sb=75.0n sa1=75.0n sa2=75.0n sa3=75.0n sa4=75.0n \
        sb1=75.0n sb2=75.0n sb3=75.0n spa=100n spa1=100n spa2=100n \
        spa3=100n sap=91.9776n sapb=114.444n spba=115.715n spba1=117.043n \
        dfm_flag=0 spmt=1.11111e+15 spomt=0 spomt1=1.11111e+60 \
        spmb=1.11111e+15 spomb=0 spomb1=1.11111e+60
    M21 (CLKNBUF net2 VSS VSS) nch_ulvt_mac l=30n w=3u multi=1 nf=3 \
        sd=100n ad=1.75e-13 as=1.75e-13 pd=4.35u ps=4.35u nrd=0.136842 \
        nrs=0.136842 sa=147.042n sb=147.042n sa1=107.158n sa2=144.915n \
        sa3=241.797n sa4=141.98n sb1=107.158n sb2=144.915n sb3=241.797n \
        spa=100n spa1=100n spa2=100n spa3=100n sap=113.519n sapb=134.009n \
        spba=115.715n spba1=117.043n dfm_flag=0 spmt=1.11111e+15 spomt=0 \
        spomt1=1.11111e+60 spmb=1.11111e+15 spomb=0 spomb1=1.11111e+60
    M23 (CLKPBUF net1 VSS VSS) nch_ulvt_mac l=30n w=3u multi=1 nf=3 \
        sd=100n ad=1.75e-13 as=1.75e-13 pd=4.35u ps=4.35u nrd=0.136842 \
        nrs=0.136842 sa=147.042n sb=147.042n sa1=107.158n sa2=144.915n \
        sa3=241.797n sa4=141.98n sb1=107.158n sb2=144.915n sb3=241.797n \
        spa=100n spa1=100n spa2=100n spa3=100n sap=113.519n sapb=134.009n \
        spba=115.715n spba1=117.043n dfm_flag=0 spmt=1.11111e+15 spomt=0 \
        spomt1=1.11111e+60 spmb=1.11111e+15 spomb=0 spomb1=1.11111e+60
    M10 (net1 net2 VDD VDD) pch_ulvt_mac l=30n w=1u multi=1 nf=2 sd=100n \
        ad=5e-14 as=7.5e-14 pd=1.2u ps=2.3u nrd=0.212518 nrs=0.212518 \
        sa=112.742n sb=112.742n sa1=93.6047n sa2=112.078n sa3=163.715n \
        sa4=110.059n sb1=93.6047n sb2=112.078n sb3=163.715n spa=100n \
        spa1=100n spa2=100n spa3=100n sap=104.359n sapb=125.813n \
        spba=115.715n spba1=117.043n dfm_flag=0 spmt=1.11111e+15 spomt=0 \
        spomt1=1.11111e+60 spmb=1.11111e+15 spomb=0 spomb1=1.11111e+60
    M5 (VDD CLKPBST net3 net3) pch_ulvt_mac l=30n w=500n multi=1 nf=2 \
        sd=100n ad=2.5e-14 as=3.75e-14 pd=700n ps=1.3u nrd=0.431634 \
        nrs=0.431634 sa=112.742n sb=112.742n sa1=93.6047n sa2=112.078n \
        sa3=163.715n sa4=110.059n sb1=93.6047n sb2=112.078n sb3=163.715n \
        spa=100n spa1=100n spa2=100n spa3=100n sap=104.359n sapb=125.813n \
        spba=115.715n spba1=117.043n dfm_flag=0 spmt=1.11111e+15 spomt=0 \
        spomt1=1.11111e+60 spmb=1.11111e+15 spomb=0 spomb1=1.11111e+60
    M4 (CLKPBST VDD net3 net3) pch_ulvt_mac l=30n w=4u multi=1 nf=8 \
        sd=100n ad=2e-13 as=2.25e-13 pd=4.8u ps=5.9u nrd=0.057867 \
        nrs=0.057867 sa=295.835n sb=295.835n sa1=149.315n sa2=274.565n \
        sa3=507.343n sa4=281.096n sb1=149.315n sb2=274.565n sb3=507.343n \
        spa=100n spa1=100n spa2=100n spa3=100n sap=142.36n sapb=158.808n \
        spba=115.715n spba1=117.043n dfm_flag=0 spmt=1.11111e+15 spomt=0 \
        spomt1=1.11111e+60 spmb=1.11111e+15 spomb=0 spomb1=1.11111e+60
    M9 (CLKPBUF net1 VDD VDD) pch_ulvt_mac l=30n w=3u multi=1 nf=3 sd=100n \
        ad=1.75e-13 as=1.75e-13 pd=4.35u ps=4.35u nrd=0.063502 \
        nrs=0.063502 sa=147.042n sb=147.042n sa1=107.158n sa2=144.915n \
        sa3=241.797n sa4=141.98n sb1=107.158n sb2=144.915n sb3=241.797n \
        spa=100n spa1=100n spa2=100n spa3=100n sap=113.519n sapb=134.009n \
        spba=115.715n spba1=117.043n dfm_flag=0 spmt=1.11111e+15 spomt=0 \
        spomt1=1.11111e+60 spmb=1.11111e+15 spomb=0 spomb1=1.11111e+60
    M0 (net2 CLKN VDD VDD) pch_ulvt_mac l=30n w=4u multi=1 nf=4 sd=100n \
        ad=2e-13 as=2.5e-13 pd=4.4u ps=6.5u nrd=0.048530 nrs=0.048530 \
        sa=179.203n sb=179.203n sa1=118.069n sa2=174.76n sa3=310.76n \
        sa4=171.966n sb1=118.069n sb2=174.76n sb3=310.76n spa=100n \
        spa1=100n spa2=100n spa3=100n sap=120.952n sapb=140.537n \
        spba=115.715n spba1=117.043n dfm_flag=0 spmt=1.11111e+15 spomt=0 \
        spomt1=1.11111e+60 spmb=1.11111e+15 spomb=0 spomb1=1.11111e+60
    M7 (CLKNBUF net2 VDD VDD) pch_ulvt_mac l=30n w=3u multi=1 nf=3 sd=100n \
        ad=1.75e-13 as=1.75e-13 pd=4.35u ps=4.35u nrd=0.063502 \
        nrs=0.063502 sa=147.042n sb=147.042n sa1=107.158n sa2=144.915n \
        sa3=241.797n sa4=141.98n sb1=107.158n sb2=144.915n sb3=241.797n \
        spa=100n spa1=100n spa2=100n spa3=100n sap=113.519n sapb=134.009n \
        spba=115.715n spba1=117.043n dfm_flag=0 spmt=1.11111e+15 spomt=0 \
        spomt1=1.11111e+60 spmb=1.11111e+15 spomb=0 spomb1=1.11111e+60
// @RNL(author="rnl-virtuoso") {
//   %block_symbol = @DEFINE-SYMBOL(box=[-10, -8, 10, 8]) {
//     @LINE {(0.5, 1) (0.5, -1)};
//     @LINE {(-0.5, 1) (-0.5, -1)};
//     @LINE {(-3, 0) (-0.5, 0)};
//     @LINE {(12, 2) (8, 2)};
//     @LINE {(-12, 0) (-8, 0)};
//     @LINE {(12, 0) (8, 0)};
//     @LINE {(-1, -10) (-1, -6)};
//     @LINE {(1, -10) (1, -6)};
//     @LINE {(12, -2) (8, -2)};
//     @LINE {(2, 1.5) (1.5, 1.5)};
//     @LINE {(1, 1.5) (1.5, 1.5)};
//     @LINE {(0.5, 0) (3, 0)};
//     @LINE {(1.5, 2) (1.5, 1)};
//     @LINE {(-2, 1.5) (-1, 1.5)};
//     @LINE {(-8, 6) (8, 6) (8, -6) (-8, -6) (-8, 6)};
//     ? @TEXT("${name}", size=1, halign="start", valign="middle", key="name") => @PLACE(6, 7);
//     ? @TEXT("${model}", size=1, halign="start", valign="middle", key="model") => @PLACE(6, 5);
//     (-12, 0) @PIN(terminal="CLKN");
//     (-7.4, 0) @TEXT("CLKN", size=1, halign="start", valign="middle");
//     (12, 0) @PIN(terminal="CLKPBST");
//     (7.4, 0) @TEXT("CLKPBST", size=1, halign="end", valign="middle");
//     (12, 2) @PIN(terminal="CLKPBUF");
//     (7.4, 2) @TEXT("CLKPBUF", size=1, halign="end", valign="middle");
//     (12, -2) @PIN(terminal="CLKNBUF");
//     (7.4, -2) @TEXT("CLKNBUF", size=1, halign="end", valign="middle");
//     (1, -10) @PIN(terminal="VSS");
//     (1, -5.4) @TEXT("VSS", size=1, halign="start", valign="middle", rotate=90);
//     (-1, -10) @PIN(terminal="VDD");
//     (-1, -5.4) @TEXT("VDD", size=1, halign="start", valign="middle", rotate=90)
//   };
//   # @SET-SYMBOL %block_symbol;
//   %symbol_0 = @DEFINE-SYMBOL(box=[-0.1, -2.8, 3.8, 2.8]) {
//     @LINE {(2, 1.5) (4, 1.5) (4, 3)};
//     @LINE {(2, -1.5) (2, 1.5)};
//     @LINE {(3, -1) (4, -1.5) (3, -2)};
//     @LINE {(0, 0) (1.5, 0)};
//     @LINE {(1.5, 1.5) (1.5, -1.5)};
//     @LINE {(2, -1.5) (4, -1.5) (4, -3)};
//     ? @TEXT("${name}", size=0.8, halign="start", valign="baseline", key="name") => @PLACE(5, 3.5);
//     ? @TEXT("${model}", size=0.8, halign="end", valign="baseline", key="model") => @PLACE(3.2, 3.2);
//     (4, -1) @PIN(terminal=4);
//     (4, -3) @PIN(terminal=3);
//     (4, 3) @PIN(terminal=1);
//     (0, 0) @PIN(terminal=2)
//   };
//   #"M21" @SET-SYMBOL %symbol_0;
//   #"M21" @PLACE(34, -48) => @ORIENT("R0");
//   %symbol_1 = @DEFINE-SYMBOL(box=[-0.1, -2.8, 3.8, 2.8]) {
//     @LINE {(0, 0) (0.7, 0)};
//     @LINE {(1.5, 1.5) (1.5, -1.5)};
//     @LINE {(2, -1.5) (4, -1.5) (4, -3)};
//     @LINE {(2, 1.5) (4, 1.5) (4, 3)};
//     (1.1, 0) @CIRCLE(radius=0.4);
//     @LINE {(3.7, 2) (2.7, 1.5) (3.7, 1)};
//     @LINE {(2, -1.5) (2, 1.5)};
//     ? @TEXT("${name}", size=0.8, halign="start", valign="baseline", key="name") => @PLACE(4.9, 3.4);
//     ? @TEXT("${model}", size=0.8, halign="end", valign="baseline", key="model") => @PLACE(3.3, 3.2);
//     (4, 3) @PIN(terminal=3);
//     (4, 1) @PIN(terminal=4);
//     (0, 0) @PIN(terminal=2);
//     (4, -3) @PIN(terminal=1)
//   };
//   #"M10" @SET-SYMBOL %symbol_1;
//   #"M10" @PLACE(34, -72) => @ORIENT("R0");
//   %symbol_2 = @DEFINE-SYMBOL(box=[-2, -6, 2, 0]) {
//     @LINE {(1, -2.2) (-1, -2.2)};
//     @LINE {(0, 0) (0, -2.2)};
//     @LINE {(0, -2.8) (0, -6)};
//     @ARC {(1, -3.2) (0, -2.8) (-1, -3.2)};
//     ? @TEXT("${name}", size=0.8, halign="start", valign="baseline", key="name") => @PLACE(1.4, 0.1);
//     ? @TEXT("${model}", size=0.8, halign="end", valign="baseline", key="model") => @PLACE(-1.1, 0.3);
//     (0, 0) @PIN(terminal=1);
//     (0, -6) @PIN(terminal=2)
//   };
//   #"C0" @SET-SYMBOL %symbol_2;
//   #"C0" @PLACE(32, 19) => @ORIENT("R0");
//   #"M23" @SET-SYMBOL %symbol_0;
//   #"M23" @PLACE(48, -88) => @ORIENT("R0");
//   #"M0" @SET-SYMBOL %symbol_1;
//   #"M0" @PLACE(12, 8) => @ORIENT("R0");
//   #"M9" @SET-SYMBOL %symbol_1;
//   #"M9" @PLACE(48, -72) => @ORIENT("R0");
//   #"M4" @SET-SYMBOL %symbol_1;
//   #"M4" @PLACE(48, 28) => @ORIENT("R90");
//   #"M19" @SET-SYMBOL %symbol_0;
//   #"M19" @PLACE(48, 4) => @ORIENT("R270");
//   #"M7" @SET-SYMBOL %symbol_1;
//   #"M7" @PLACE(34, -32) => @ORIENT("R0");
//   #"M5" @SET-SYMBOL %symbol_1;
//   #"M5" @PLACE(36, 40) => @ORIENT("R180");
//   #"M24" @SET-SYMBOL %symbol_0;
//   #"M24" @PLACE(34, -88) => @ORIENT("R0");
//   #"M15" @SET-SYMBOL %symbol_0;
//   #"M15" @PLACE(12, -8) => @ORIENT("R0");
//   %port_0 = $IO_PORT @ATTACH &"VSS" => @PLACE(-17, 28) => @ORIENT("R0");
//   %input_port_symbol = @DEFINE-SYMBOL(box=[-2, -1, 0, 1]) {
//       @LINE(fill="linecolor", linestyle="none") {(-2, -0.9) (-2, 0.9) (-0.9, 0.9) (0, 0) (-0.9, -0.9) (-2, -0.9)};
//       (0, 0) @PIN(terminal=1, direction="right");
//       ? @TEXT("${name}", key="name", halign="middle") => @PLACE(-1, 1.6)
//     };
//   %port_1 = $IO_PORT @ATTACH &"CLKN" => @PLACE(0, 0) => @ORIENT("R0");
//   %port_1 @SET-SYMBOL %input_port_symbol;
//   %port_1 @TEXT("CLKN", key="name");
//   %output_port_symbol = @DEFINE-SYMBOL(box=[0, -1, 2, 1]) {
//       @LINE(fill="linecolor", linestyle="none") {(0, -0.9) (0, 0.9) (1.1, 0.9) (2, 0) (1.1, -0.9) (0, -0.9)};
//       (0, 0) @PIN(terminal=1, direction="left");
//       ? @TEXT("${name}", key="name", halign="middle") => @PLACE(1, 1.6)
//     };
//   %port_2 = $IO_PORT @ATTACH &"CLKPBUF" => @PLACE(61, -80) => @ORIENT("R0");
//   %port_2 @SET-SYMBOL %output_port_symbol;
//   %port_2 @TEXT("CLKPBUF", key="name");
//   %port_3 = $IO_PORT @ATTACH &"CLKPBST" => @PLACE(64, 16) => @ORIENT("R0");
//   %port_3 @SET-SYMBOL %output_port_symbol;
//   %port_3 @TEXT("CLKPBST", key="name");
//   %port_4 = $IO_PORT @ATTACH &"VDD" => @PLACE(-17, 32) => @ORIENT("R0");
//   %port_5 = $IO_PORT @ATTACH &"CLKNBUF" => @PLACE(47, -40) => @ORIENT("R0");
//   %port_5 @SET-SYMBOL %output_port_symbol;
//   %port_5 @TEXT("CLKNBUF", key="name");
//   %p0 = (32, -88);
//   %p1 = (32, -80);
//   %wire_0 = &"net2" @WIRE(mode="straight") {%p0 %p1};
//   %p2 = (24, -80);
//   %p3 = (24, -40);
//   %wire_1 = &"net2" @WIRE(mode="straight") {%p2 %p3};
//   %p4 = (32, -72);
//   %wire_2 = &"net2" @WIRE(mode="straight") {%p1 %p4};
//   %p5 = (24, 0);
//   %wire_3 = &"net2" @WIRE(mode="straight") {%p3 %p5};
//   %wire_4 = &"net2" @WIRE(mode="straight") {%p2 %p1};
//   %wire_5 = &"net2" @WIRE(mode="straight") {%p0 #"M24":2};
//   %wire_6 = &"net2" @WIRE(mode="straight") {%p4 #"M10":2};
//   %p6 = (32, 0);
//   %wire_7 = &"net2" @WIRE(mode="straight") {%p6 #"M19":3};
//   %p7 = (32, -48);
//   %p8 = (32, -40);
//   %wire_8 = &"net2" @WIRE(mode="straight") {%p7 %p8};
//   %p9 = (32, -32);
//   %wire_9 = &"net2" @WIRE(mode="straight") {%p8 %p9};
//   %wire_10 = &"net2" @WIRE(mode="straight") {%p7 #"M21":2};
//   %wire_11 = &"net2" @WIRE(mode="straight") {%p5 %p6};
//   %wire_12 = &"net2" @WIRE(mode="straight") {%p6 #"C0":2};
//   %p10 = (16, 0);
//   %wire_13 = &"net2" @WIRE(mode="straight") {%p10 %p5};
//   %wire_14 = &"net2" @WIRE(mode="straight") {%p3 %p8};
//   %wire_15 = &"net2" @WIRE(mode="straight") {%p10 #"M0":1};
//   %wire_16 = &"net2" @WIRE(mode="straight") {#"M15":1 %p10};
//   %wire_17 = &"net2" @WIRE(mode="straight") {%p9 #"M7":2};
//   %p11 = (38, -80);
//   %p12 = (46, -80);
//   %wire_18 = &"net1" @WIRE(mode="straight") {%p11 %p12};
//   %wire_19 = &"net1" @WIRE(mode="straight") {#"M24":1 %p11};
//   %p13 = (46, -72);
//   %wire_20 = &"net1" @WIRE(mode="straight") {%p12 %p13};
//   %p14 = (46, -88);
//   %wire_21 = &"net1" @WIRE(mode="straight") {%p14 %p12};
//   %wire_22 = &"net1" @WIRE(mode="straight") {%p11 #"M10":1};
//   %wire_23 = &"net1" @WIRE(mode="straight") {%p14 #"M23":2};
//   %wire_24 = &"net1" @WIRE(mode="straight") {%p13 #"M9":2};
//   %p15 = (52, -80);
//   %wire_25 = &"CLKPBUF" @WIRE(mode="straight") {%p15 %port_2:p};
//   %wire_26 = &"CLKPBUF" @WIRE(mode="straight") {%p15 #"M9":1};
//   %wire_27 = &"CLKPBUF" @WIRE(mode="straight") {#"M23":1 %p15};
//   %p16 = (38, -40);
//   %wire_28 = &"CLKNBUF" @WIRE(mode="straight") {%p16 %port_5:p};
//   %wire_29 = &"CLKNBUF" @WIRE(mode="straight") {%p16 #"M7":1};
//   %wire_30 = &"CLKNBUF" @WIRE(mode="straight") {#"M21":1 %p16};
//   %p17 = (39, -71);
//   %p18 = (39, -69);
//   %wire_31 = &"VDD" @WIRE(mode="straight") {%p17 %p18};
//   %p19 = (38, -64);
//   %wire_32 = &"VDD" @WIRE(mode="straight") {#"M10":3 %p19};
//   %wire_33 = &"VDD" @WIRE(mode="straight") {#"M10":4 %p17};
//   %wire_34 = &"VDD" @WIRE(mode="straight") {#"M10":3 %p18};
//   %p20 = (53, -71);
//   %p21 = (53, -69);
//   %wire_35 = &"VDD" @WIRE(mode="straight") {%p20 %p21};
//   %p22 = (17, 11);
//   %wire_36 = &"VDD" @WIRE(mode="straight") {#"M0":3 %p22};
//   %p23 = (17, 9);
//   %wire_37 = &"VDD" @WIRE(mode="straight") {%p23 %p22};
//   %wire_38 = &"VDD" @WIRE(mode="straight") {#"M0":4 %p23};
//   %p24 = (52, -64);
//   %wire_39 = &"VDD" @WIRE(mode="straight") {#"M9":3 %p24};
//   %wire_40 = &"VDD" @WIRE(mode="straight") {#"M9":4 %p20};
//   %wire_41 = &"VDD" @WIRE(mode="straight") {#"M9":3 %p21};
//   %p25 = (39, -31);
//   %p26 = (39, -29);
//   %wire_42 = &"VDD" @WIRE(mode="straight") {%p25 %p26};
//   %p27 = (48, 24);
//   %wire_43 = &"VDD" @WIRE(mode="straight") {%p27 #"M4":2};
//   %wire_44 = &"VDD" @WIRE(mode="straight") {#"M7":4 %p25};
//   %wire_45 = &"VDD" @WIRE(mode="straight") {#"M7":3 %p26};
//   %p28 = (32, 48);
//   %wire_46 = &"VDD" @WIRE(mode="straight") {#"M5":1 %p28};
//   %p29 = (48, 8);
//   %wire_47 = &"VDD" @WIRE(mode="straight") {%p29 #"M19":2};
//   %p30 = (16, 16);
//   %wire_48 = &"VDD" @WIRE(mode="straight") {#"M0":3 %p30};
//   %p31 = (38, -24);
//   %wire_49 = &"VDD" @WIRE(mode="straight") {#"M7":3 %p31};
//   %wire_49 @TEXT("VDD", size=1, halign="middle", valign="baseline", rotate=90) => @PLACE(37.3, -26);
//   %wire_47 @TEXT("VDD", size=1, halign="middle", valign="baseline", rotate=90) => @PLACE(47.3, 6);
//   %wire_48 @TEXT("VDD", size=1, halign="middle", valign="baseline", rotate=90) => @PLACE(15.3, 14);
//   %wire_46 @TEXT("VDD", size=1, halign="middle", valign="baseline", rotate=90) => @PLACE(31.3, 46);
//   %wire_39 @TEXT("VDD", size=1, halign="middle", valign="baseline", rotate=90) => @PLACE(51.3, -66);
//   %wire_43 @TEXT("VDD", size=1, halign="middle", valign="baseline", rotate=90) => @PLACE(47.3, 25);
//   %wire_32 @TEXT("VDD", size=1, halign="middle", valign="baseline", rotate=90) => @PLACE(37.3, -66);
//   %p32 = (45, 33);
//   %p33 = (47, 33);
//   %wire_50 = &"net3" @WIRE(mode="straight") {%p32 %p33};
//   %p34 = (31, 37);
//   %wire_51 = &"net3" @WIRE(mode="straight") {%p34 #"M5":3};
//   %p35 = (31, 39);
//   %wire_52 = &"net3" @WIRE(mode="straight") {%p34 %p35};
//   %wire_53 = &"net3" @WIRE(mode="straight") {#"M4":3 %p32};
//   %wire_54 = &"net3" @WIRE(mode="straight") {#"M4":4 %p33};
//   %wire_55 = &"net3" @WIRE(mode="straight") {%p35 #"M5":4};
//   %p36 = (32, 32);
//   %wire_56 = &"net3" @WIRE(mode="straight") {%p36 #"M4":3};
//   %wire_57 = &"net3" @WIRE(mode="straight") {#"C0":1 %p36};
//   %wire_58 = &"net3" @WIRE(mode="straight") {%p36 #"M5":3};
//   %p37 = (-1, 0);
//   %p38 = (10, 0);
//   %wire_59 = &"CLKN" @WIRE(mode="straight") {%p37 %port_1:p %p38};
//   %p39 = (10, 8);
//   %wire_60 = &"CLKN" @WIRE(mode="straight") {%p38 %p39};
//   %p40 = (10, -8);
//   %wire_61 = &"CLKN" @WIRE(mode="straight") {%p40 %p38};
//   %wire_62 = &"CLKN" @WIRE(mode="straight") {%p40 #"M15":2};
//   %wire_63 = &"CLKN" @WIRE(mode="straight") {%p39 #"M0":2};
//   %p41 = (56, 40);
//   %wire_64 = &"CLKPBST" @WIRE(mode="straight") {#"M5":2 %p41};
//   %p42 = (56, 32);
//   %wire_65 = &"CLKPBST" @WIRE(mode="straight") {%p42 %p41};
//   %p43 = (56, 16);
//   %wire_66 = &"CLKPBST" @WIRE(mode="straight") {%p43 %port_3:p};
//   %p44 = (56, 0);
//   %wire_67 = &"CLKPBST" @WIRE(mode="straight") {%p44 %p43};
//   %wire_68 = &"CLKPBST" @WIRE(mode="straight") {%p43 %p42};
//   %wire_69 = &"CLKPBST" @WIRE(mode="straight") {#"M4":1 %p42};
//   %wire_70 = &"CLKPBST" @WIRE(mode="straight") {#"M19":1 %p44};
//   %p45 = (38, -96);
//   %wire_71 = &"VSS" @WIRE(mode="straight") {%p45 #"M24":3};
//   %p46 = (39, -89);
//   %wire_72 = &"VSS" @WIRE(mode="straight") {#"M24":4 %p46};
//   %p47 = (39, -91);
//   %wire_73 = &"VSS" @WIRE(mode="straight") {#"M24":3 %p47};
//   %p48 = (17, -11);
//   %wire_74 = &"VSS" @WIRE(mode="straight") {#"M15":3 %p48};
//   %p49 = (52, -96);
//   %wire_75 = &"VSS" @WIRE(mode="straight") {%p49 #"M23":3};
//   %p50 = (17, -9);
//   %wire_76 = &"VSS" @WIRE(mode="straight") {#"M15":4 %p50};
//   %wire_77 = &"VSS" @WIRE(mode="straight") {%p47 %p46};
//   %p51 = (53, -89);
//   %wire_78 = &"VSS" @WIRE(mode="straight") {#"M23":4 %p51};
//   %p52 = (53, -91);
//   %wire_79 = &"VSS" @WIRE(mode="straight") {#"M23":3 %p52};
//   %wire_80 = &"VSS" @WIRE(mode="straight") {%p52 %p51};
//   %p53 = (47, -4);
//   %wire_81 = &"VSS" @WIRE(mode="straight") {%p53 #"M19":4};
//   %wire_82 = &"VSS" @WIRE(mode="straight") {%p48 %p50};
//   %p54 = (39, -51);
//   %p55 = (39, -49);
//   %wire_83 = &"VSS" @WIRE(mode="straight") {%p54 %p55};
//   %wire_84 = &"VSS" @WIRE(mode="straight") {#"M21":4 %p55};
//   %wire_85 = &"VSS" @WIRE(mode="straight") {#"M21":3 %p54};
//   %p56 = (38, -56);
//   %wire_86 = &"VSS" @WIRE(mode="straight") {%p56 #"M21":3};
//   %p57 = (16, -16);
//   %wire_87 = &"VSS" @WIRE(mode="straight") {%p57 #"M15":3};
//   %wire_86 @TEXT("VSS", size=1, halign="middle", valign="baseline", rotate=90) => @PLACE(37.3, -54);
//   %wire_81 @TEXT("VSS", size=1, halign="middle", valign="baseline", rotate=90) => @PLACE(46.3, -3);
//   %wire_87 @TEXT("VSS", size=1, halign="middle", valign="baseline", rotate=90) => @PLACE(15.3, -14);
//   %wire_75 @TEXT("VSS", size=1, halign="middle", valign="baseline", rotate=90) => @PLACE(51.3, -94);
//   %wire_71 @TEXT("VSS", size=1, halign="middle", valign="baseline", rotate=90) => @PLACE(37.3, -94);
//   $JUNCTION @ATTACH %p1;
//   $JUNCTION @ATTACH %p3;
//   $JUNCTION @ATTACH %p5;
//   $JUNCTION @ATTACH %p6;
//   $JUNCTION @ATTACH %p8;
//   $JUNCTION @ATTACH %p10;
//   $JUNCTION @ATTACH %p11;
//   $JUNCTION @ATTACH %p12;
//   $JUNCTION @ATTACH %p15;
//   $JUNCTION @ATTACH %p16;
//   $JUNCTION @ATTACH %p36;
//   $JUNCTION @ATTACH %p38;
//   $JUNCTION @ATTACH %p42;
//   $JUNCTION @ATTACH %p43
// }
ends L4_stage1_flash_clkbooster
