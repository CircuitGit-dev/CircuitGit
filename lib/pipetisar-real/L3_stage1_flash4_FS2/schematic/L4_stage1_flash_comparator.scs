// RNL cell 2026_PIPETISAR_RESEARCH/L4_stage1_flash_comparator
// @RNL(type="header") {
//   @VERSION("0.3");
//   @USE-PACKAGE(name="rnl-std-spectre", version="0.3", path="rnl-std-spectre.rnl");
//   @USE-PACKAGE(name="eda-symbol", version="0.1", path="eda-symbol.rnl");
//   @USE-PACKAGE(name="eda-style", version="0.1", path="eda-style.rnl")
// }
subckt L4_stage1_flash_comparator D DN DP PHI1BSTN PHI1BSTP PHI1EN PHI1EP \
        PHI1EPBST PHI2N PHI2P VB VCM VDD VINN VINP VOSN VOSP VREFN VREFP \
        VSS
    M1 (VSS VB VSS VSS) nch_mac l=90n w=1u multi=1 nf=2 sd=100n ad=5e-14 \
        as=7.5e-14 pd=1.2u ps=2.3u nrd=0.425847 nrs=0.425847 sa=128.023n \
        sb=128.023n sa1=95.836n sa2=126.274n sa3=206.685n sa4=117.256n \
        sb1=95.836n sb2=126.274n sb3=206.685n spa=100n spa1=100n spa2=100n \
        spa3=100n sap=106.564n sapb=139.945n spba=131.097n spba1=134.93n \
        dfm_flag=0 spmt=1.11111e+15 spomt=0 spomt1=1.11111e+60 \
        spmb=1.11111e+15 spomb=0 spomb1=1.11111e+60
    M0 (net3 VB VSS VSS) nch_mac l=90n w=4u multi=1 nf=8 sd=100n ad=2e-13 \
        as=2.25e-13 pd=4.8u ps=5.9u nrd=0.135370 nrs=0.135370 sa=385.973n \
        sb=385.973n sa1=156.875n sa2=340.187n sa3=605.428n sa4=327.556n \
        sb1=156.875n sb2=340.187n sb3=605.428n spa=100n spa1=100n \
        spa2=100n spa3=100n sap=149.779n sapb=188.916n spba=139.847n \
        spba1=143.418n dfm_flag=0 spmt=1.11111e+15 spomt=0 \
        spomt1=1.11111e+60 spmb=1.11111e+15 spomb=0 spomb1=1.11111e+60
    I13 (D DP VDD VSS net15) ND2D0BWP12T30P140ULVT
    I16 (net15 DN VDD VSS D) ND2D0BWP12T30P140ULVT
    I3 (VREFP PHI2P PHI2N VSS VDD net11) trans_ulvt_mac_pcell_0 p_lgb=30n \
        p_tw=500n p_simM=1 p_f=1 p_sdgb=100n p_ad=37.5f p_as=37.5f \
        p_pd=1.15u p_ps=1.15u p_nrd=383.209m p_nrs=383.209m p_sa=75.0n \
        p_sb=75.0n p_sca=104.19 p_scb=93.0269m p_scc=15.3972m p_sa1=75.0n \
        p_sa2=75.0n p_sa3=75.0n p_sa4=75.0n p_sb1=75.0n p_sb2=75.0n \
        p_sb3=75.0n p_spa=100n p_spa1=100n p_spa2=100n p_spa3=100n \
        p_sap=91.9776n p_sapb=114.444n p_spba=115.715n p_spba1=117.043n \
        p_sa5=75.0n p_sa6=75.0n p_sodx=80n p_sodxa=80n p_sodxb=80n \
        p_sodx1=140.457n p_sodx2=763.66n p_sody=505.00n p_dw1=-1.4923e-20 \
        p_sa7=75.0n p_sodx4=76.6549n p_spmt=1.11111e+15 p_spomt=0 \
        p_spomt1=1.11111e+60 p_spmb=1.11111e+15 p_spomb=0 \
        p_spomb1=1.11111e+60 n_lgb=30n n_tw=500n n_simM=1 n_f=1 \
        n_sdgb=100n n_ad=37.5f n_as=37.5f n_pd=1.15u n_ps=1.15u \
        n_nrd=662.935m n_nrs=662.935m n_sa=75.0n n_sb=75.0n n_sca=104.19 \
        n_scb=93.0269m n_scc=15.3972m n_sa1=75.0n n_sa2=75.0n n_sa3=75.0n \
        n_sa4=75.0n n_sb1=75.0n n_sb2=75.0n n_sb3=75.0n n_spa=100n \
        n_spa1=100n n_spa2=100n n_spa3=100n n_sap=91.9776n n_sapb=114.444n \
        n_spba=115.715n n_spba1=117.043n n_sa5=75.0n n_sa6=75.0n \
        n_sodx=80n n_sodxa=80n n_sodxb=80n n_sodx1=140.457n \
        n_sodx2=763.66n n_sody=505.00n n_dw1=-1.4923e-20 n_sa7=75.0n \
        n_sodx4=76.6549n n_spmt=1.11111e+15 n_spomt=0 n_spomt1=1.11111e+60 \
        n_spmb=1.11111e+15 n_spomb=0 n_spomb1=1.11111e+60
    I7 (VCM PHI2P PHI2N VSS VDD VINP0) trans_ulvt_mac_pcell_0 p_lgb=30n \
        p_tw=500n p_simM=1 p_f=1 p_sdgb=100n p_ad=37.5f p_as=37.5f \
        p_pd=1.15u p_ps=1.15u p_nrd=383.209m p_nrs=383.209m p_sa=75.0n \
        p_sb=75.0n p_sca=104.19 p_scb=93.0269m p_scc=15.3972m p_sa1=75.0n \
        p_sa2=75.0n p_sa3=75.0n p_sa4=75.0n p_sb1=75.0n p_sb2=75.0n \
        p_sb3=75.0n p_spa=100n p_spa1=100n p_spa2=100n p_spa3=100n \
        p_sap=91.9776n p_sapb=114.444n p_spba=115.715n p_spba1=117.043n \
        p_sa5=75.0n p_sa6=75.0n p_sodx=80n p_sodxa=80n p_sodxb=80n \
        p_sodx1=140.457n p_sodx2=763.66n p_sody=505.00n p_dw1=-1.4923e-20 \
        p_sa7=75.0n p_sodx4=76.6549n p_spmt=1.11111e+15 p_spomt=0 \
        p_spomt1=1.11111e+60 p_spmb=1.11111e+15 p_spomb=0 \
        p_spomb1=1.11111e+60 n_lgb=30n n_tw=500n n_simM=1 n_f=1 \
        n_sdgb=100n n_ad=37.5f n_as=37.5f n_pd=1.15u n_ps=1.15u \
        n_nrd=662.935m n_nrs=662.935m n_sa=75.0n n_sb=75.0n n_sca=104.19 \
        n_scb=93.0269m n_scc=15.3972m n_sa1=75.0n n_sa2=75.0n n_sa3=75.0n \
        n_sa4=75.0n n_sb1=75.0n n_sb2=75.0n n_sb3=75.0n n_spa=100n \
        n_spa1=100n n_spa2=100n n_spa3=100n n_sap=91.9776n n_sapb=114.444n \
        n_spba=115.715n n_spba1=117.043n n_sa5=75.0n n_sa6=75.0n \
        n_sodx=80n n_sodxa=80n n_sodxb=80n n_sodx1=140.457n \
        n_sodx2=763.66n n_sody=505.00n n_dw1=-1.4923e-20 n_sa7=75.0n \
        n_sodx4=76.6549n n_spmt=1.11111e+15 n_spomt=0 n_spomt1=1.11111e+60 \
        n_spmb=1.11111e+15 n_spomb=0 n_spomb1=1.11111e+60
    I5 (VREFN PHI2P PHI2N VSS VDD net6) trans_ulvt_mac_pcell_0 p_lgb=30n \
        p_tw=500n p_simM=1 p_f=1 p_sdgb=100n p_ad=37.5f p_as=37.5f \
        p_pd=1.15u p_ps=1.15u p_nrd=383.209m p_nrs=383.209m p_sa=75.0n \
        p_sb=75.0n p_sca=104.19 p_scb=93.0269m p_scc=15.3972m p_sa1=75.0n \
        p_sa2=75.0n p_sa3=75.0n p_sa4=75.0n p_sb1=75.0n p_sb2=75.0n \
        p_sb3=75.0n p_spa=100n p_spa1=100n p_spa2=100n p_spa3=100n \
        p_sap=91.9776n p_sapb=114.444n p_spba=115.715n p_spba1=117.043n \
        p_sa5=75.0n p_sa6=75.0n p_sodx=80n p_sodxa=80n p_sodxb=80n \
        p_sodx1=140.457n p_sodx2=763.66n p_sody=505.00n p_dw1=-1.4923e-20 \
        p_sa7=75.0n p_sodx4=76.6549n p_spmt=1.11111e+15 p_spomt=0 \
        p_spomt1=1.11111e+60 p_spmb=1.11111e+15 p_spomb=0 \
        p_spomb1=1.11111e+60 n_lgb=30n n_tw=500n n_simM=1 n_f=1 \
        n_sdgb=100n n_ad=37.5f n_as=37.5f n_pd=1.15u n_ps=1.15u \
        n_nrd=662.935m n_nrs=662.935m n_sa=75.0n n_sb=75.0n n_sca=104.19 \
        n_scb=93.0269m n_scc=15.3972m n_sa1=75.0n n_sa2=75.0n n_sa3=75.0n \
        n_sa4=75.0n n_sb1=75.0n n_sb2=75.0n n_sb3=75.0n n_spa=100n \
        n_spa1=100n n_spa2=100n n_spa3=100n n_sap=91.9776n n_sapb=114.444n \
        n_spba=115.715n n_spba1=117.043n n_sa5=75.0n n_sa6=75.0n \
        n_sodx=80n n_sodxa=80n n_sodxb=80n n_sodx1=140.457n \
        n_sodx2=763.66n n_sody=505.00n n_dw1=-1.4923e-20 n_sa7=75.0n \
        n_sodx4=76.6549n n_spmt=1.11111e+15 n_spomt=0 n_spomt1=1.11111e+60 \
        n_spmb=1.11111e+15 n_spomb=0 n_spomb1=1.11111e+60
    I8 (VCM PHI2P PHI2N VSS VDD VINN0) trans_ulvt_mac_pcell_0 p_lgb=30n \
        p_tw=500n p_simM=1 p_f=1 p_sdgb=100n p_ad=37.5f p_as=37.5f \
        p_pd=1.15u p_ps=1.15u p_nrd=383.209m p_nrs=383.209m p_sa=75.0n \
        p_sb=75.0n p_sca=104.19 p_scb=93.0269m p_scc=15.3972m p_sa1=75.0n \
        p_sa2=75.0n p_sa3=75.0n p_sa4=75.0n p_sb1=75.0n p_sb2=75.0n \
        p_sb3=75.0n p_spa=100n p_spa1=100n p_spa2=100n p_spa3=100n \
        p_sap=91.9776n p_sapb=114.444n p_spba=115.715n p_spba1=117.043n \
        p_sa5=75.0n p_sa6=75.0n p_sodx=80n p_sodxa=80n p_sodxb=80n \
        p_sodx1=140.457n p_sodx2=763.66n p_sody=505.00n p_dw1=-1.4923e-20 \
        p_sa7=75.0n p_sodx4=76.6549n p_spmt=1.11111e+15 p_spomt=0 \
        p_spomt1=1.11111e+60 p_spmb=1.11111e+15 p_spomb=0 \
        p_spomb1=1.11111e+60 n_lgb=30n n_tw=500n n_simM=1 n_f=1 \
        n_sdgb=100n n_ad=37.5f n_as=37.5f n_pd=1.15u n_ps=1.15u \
        n_nrd=662.935m n_nrs=662.935m n_sa=75.0n n_sb=75.0n n_sca=104.19 \
        n_scb=93.0269m n_scc=15.3972m n_sa1=75.0n n_sa2=75.0n n_sa3=75.0n \
        n_sa4=75.0n n_sb1=75.0n n_sb2=75.0n n_sb3=75.0n n_spa=100n \
        n_spa1=100n n_spa2=100n n_spa3=100n n_sap=91.9776n n_sapb=114.444n \
        n_spba=115.715n n_spba1=117.043n n_sa5=75.0n n_sa6=75.0n \
        n_sodx=80n n_sodxa=80n n_sodxb=80n n_sodx1=140.457n \
        n_sodx2=763.66n n_sody=505.00n n_dw1=-1.4923e-20 n_sa7=75.0n \
        n_sodx4=76.6549n n_spmt=1.11111e+15 n_spomt=0 n_spomt1=1.11111e+60 \
        n_spmb=1.11111e+15 n_spomb=0 n_spomb1=1.11111e+60
    C3 (net11 VINP0) cfmom_2t nr=12 lr=2.5u w=50n s=50n stm=3 spm=7 \
        multi=1
    C4 (net6 VINN0) cfmom_2t nr=12 lr=2.5u w=50n s=50n stm=3 spm=7 multi=1
    M58 (net2 PHI1EP VDD VDD) pch_ulvt_mac l=30n w=2u multi=1 nf=4 sd=100n \
        ad=1e-13 as=1.25e-13 pd=2.4u ps=3.5u nrd=0.112393 nrs=0.112393 \
        sa=179.203n sb=179.203n sa1=118.069n sa2=174.76n sa3=310.76n \
        sa4=171.966n sb1=118.069n sb2=174.76n sb3=310.76n spa=100n \
        spa1=100n spa2=100n spa3=100n sap=120.952n sapb=140.537n \
        spba=115.715n spba1=117.043n dfm_flag=0 spmt=1.11111e+15 spomt=0 \
        spomt1=1.11111e+60 spmb=1.11111e+15 spomb=0 spomb1=1.11111e+60
    M87 (VMP VMN net2 VDD) pch_ulvt_mac l=30n w=1u multi=1 nf=2 sd=100n \
        ad=5e-14 as=7.5e-14 pd=1.2u ps=2.3u nrd=0.212518 nrs=0.212518 \
        sa=112.742n sb=112.742n sa1=93.6047n sa2=112.078n sa3=163.715n \
        sa4=110.059n sb1=93.6047n sb2=112.078n sb3=163.715n spa=100n \
        spa1=100n spa2=100n spa3=100n sap=104.359n sapb=125.813n \
        spba=115.715n spba1=117.043n dfm_flag=0 spmt=1.11111e+15 spomt=0 \
        spomt1=1.11111e+60 spmb=1.11111e+15 spomb=0 spomb1=1.11111e+60
    M12 (VMN VMP net2 VDD) pch_ulvt_mac l=30n w=1u multi=1 nf=2 sd=100n \
        ad=5e-14 as=7.5e-14 pd=1.2u ps=2.3u nrd=0.212518 nrs=0.212518 \
        sa=112.742n sb=112.742n sa1=93.6047n sa2=112.078n sa3=163.715n \
        sa4=110.059n sb1=93.6047n sb2=112.078n sb3=163.715n spa=100n \
        spa1=100n spa2=100n spa3=100n sap=104.359n sapb=125.813n \
        spba=115.715n spba1=117.043n dfm_flag=0 spmt=1.11111e+15 spomt=0 \
        spomt1=1.11111e+60 spmb=1.11111e+15 spomb=0 spomb1=1.11111e+60
    M21 (net7 VMP net2 VDD) pch_ulvt_mac l=30n w=500n multi=1 nf=1 sd=100n \
        ad=3.75e-14 as=3.75e-14 pd=1.15u ps=1.15u nrd=0.383209 \
        nrs=0.383209 sa=75.0n sb=75.0n sa1=75.0n sa2=75.0n sa3=75.0n \
        sa4=75.0n sb1=75.0n sb2=75.0n sb3=75.0n spa=100n spa1=100n \
        spa2=100n spa3=100n sap=91.9776n sapb=114.444n spba=115.715n \
        spba1=117.043n dfm_flag=0 spmt=1.11111e+15 spomt=0 \
        spomt1=1.11111e+60 spmb=1.11111e+15 spomb=0 spomb1=1.11111e+60
    M22 (net9 VMN net2 VDD) pch_ulvt_mac l=30n w=500n multi=1 nf=1 sd=100n \
        ad=3.75e-14 as=3.75e-14 pd=1.15u ps=1.15u nrd=0.383209 \
        nrs=0.383209 sa=75.0n sb=75.0n sa1=75.0n sa2=75.0n sa3=75.0n \
        sa4=75.0n sb1=75.0n sb2=75.0n sb3=75.0n spa=100n spa1=100n \
        spa2=100n spa3=100n sap=91.9776n sapb=114.444n spba=115.715n \
        spba1=117.043n dfm_flag=0 spmt=1.11111e+15 spomt=0 \
        spomt1=1.11111e+60 spmb=1.11111e+15 spomb=0 spomb1=1.11111e+60
    M30 (DN net9 VDD VDD) pch_ulvt_mac l=30n w=1u multi=1 nf=4 sd=100n \
        ad=5e-14 as=6.25e-14 pd=1.4u ps=2u nrd=0.228368 nrs=0.228368 \
        sa=179.203n sb=179.203n sa1=118.069n sa2=174.76n sa3=310.76n \
        sa4=171.966n sb1=118.069n sb2=174.76n sb3=310.76n spa=100n \
        spa1=100n spa2=100n spa3=100n sap=120.952n sapb=140.537n \
        spba=115.715n spba1=117.043n dfm_flag=0 spmt=1.11111e+15 spomt=0 \
        spomt1=1.11111e+60 spmb=1.11111e+15 spomb=0 spomb1=1.11111e+60
    M31 (DN PHI2P VDD VDD) pch_ulvt_mac l=30n w=1u multi=1 nf=4 sd=100n \
        ad=5e-14 as=6.25e-14 pd=1.4u ps=2u nrd=0.228368 nrs=0.228368 \
        sa=179.203n sb=179.203n sa1=118.069n sa2=174.76n sa3=310.76n \
        sa4=171.966n sb1=118.069n sb2=174.76n sb3=310.76n spa=100n \
        spa1=100n spa2=100n spa3=100n sap=120.952n sapb=140.537n \
        spba=115.715n spba1=117.043n dfm_flag=0 spmt=1.11111e+15 spomt=0 \
        spomt1=1.11111e+60 spmb=1.11111e+15 spomb=0 spomb1=1.11111e+60
    M37 (DP PHI2P VDD VDD) pch_ulvt_mac l=30n w=1u multi=1 nf=4 sd=100n \
        ad=5e-14 as=6.25e-14 pd=1.4u ps=2u nrd=0.228368 nrs=0.228368 \
        sa=179.203n sb=179.203n sa1=118.069n sa2=174.76n sa3=310.76n \
        sa4=171.966n sb1=118.069n sb2=174.76n sb3=310.76n spa=100n \
        spa1=100n spa2=100n spa3=100n sap=120.952n sapb=140.537n \
        spba=115.715n spba1=117.043n dfm_flag=0 spmt=1.11111e+15 spomt=0 \
        spomt1=1.11111e+60 spmb=1.11111e+15 spomb=0 spomb1=1.11111e+60
    M38 (DP net7 VDD VDD) pch_ulvt_mac l=30n w=1u multi=1 nf=4 sd=100n \
        ad=5e-14 as=6.25e-14 pd=1.4u ps=2u nrd=0.228368 nrs=0.228368 \
        sa=179.203n sb=179.203n sa1=118.069n sa2=174.76n sa3=310.76n \
        sa4=171.966n sb1=118.069n sb2=174.76n sb3=310.76n spa=100n \
        spa1=100n spa2=100n spa3=100n sap=120.952n sapb=140.537n \
        spba=115.715n spba1=117.043n dfm_flag=0 spmt=1.11111e+15 spomt=0 \
        spomt1=1.11111e+60 spmb=1.11111e+15 spomb=0 spomb1=1.11111e+60
    M57 (VMP PHI1EPBST net4 VSS) nch_ulvt_mac l=30n w=250.0n multi=1 nf=1 \
        sd=100n ad=1.875e-14 as=1.875e-14 pd=650.0n ps=650.0n nrd=1.338763 \
        nrs=1.338763 sa=75.0n sb=75.0n sa1=75.0n sa2=75.0n sa3=75.0n \
        sa4=75.0n sb1=75.0n sb2=75.0n sb3=75.0n spa=100n spa1=100n \
        spa2=100n spa3=100n sap=91.9776n sapb=114.444n spba=115.715n \
        spba1=117.043n dfm_flag=0 spmt=1.11111e+15 spomt=0 \
        spomt1=1.11111e+60 spmb=1.11111e+15 spomb=0 spomb1=1.11111e+60
    M56 (VMN PHI1EPBST net1 VSS) nch_ulvt_mac l=30n w=250.0n multi=1 nf=1 \
        sd=100n ad=1.875e-14 as=1.875e-14 pd=650.0n ps=650.0n nrd=1.338763 \
        nrs=1.338763 sa=75.0n sb=75.0n sa1=75.0n sa2=75.0n sa3=75.0n \
        sa4=75.0n sb1=75.0n sb2=75.0n sb3=75.0n spa=100n spa1=100n \
        spa2=100n spa3=100n sap=91.9776n sapb=114.444n spba=115.715n \
        spba1=117.043n dfm_flag=0 spmt=1.11111e+15 spomt=0 \
        spomt1=1.11111e+60 spmb=1.11111e+15 spomb=0 spomb1=1.11111e+60
    M62 (net1 VDD net4 VSS) nch_ulvt_mac l=30n w=250.0n multi=1 nf=1 \
        sd=100n ad=1.875e-14 as=1.875e-14 pd=650.0n ps=650.0n nrd=1.338763 \
        nrs=1.338763 sa=75.0n sb=75.0n sa1=75.0n sa2=75.0n sa3=75.0n \
        sa4=75.0n sb1=75.0n sb2=75.0n sb3=75.0n spa=100n spa1=100n \
        spa2=100n spa3=100n sap=91.9776n sapb=114.444n spba=115.715n \
        spba1=117.043n dfm_flag=0 spmt=1.11111e+15 spomt=0 \
        spomt1=1.11111e+60 spmb=1.11111e+15 spomb=0 spomb1=1.11111e+60
    M23 (net9 VMN VSS VSS) nch_ulvt_mac l=30n w=500n multi=1 nf=1 sd=100n \
        ad=3.75e-14 as=3.75e-14 pd=1.15u ps=1.15u nrd=0.662935 \
        nrs=0.662935 sa=75.0n sb=75.0n sa1=75.0n sa2=75.0n sa3=75.0n \
        sa4=75.0n sb1=75.0n sb2=75.0n sb3=75.0n spa=100n spa1=100n \
        spa2=100n spa3=100n sap=91.9776n sapb=114.444n spba=115.715n \
        spba1=117.043n dfm_flag=0 spmt=1.11111e+15 spomt=0 \
        spomt1=1.11111e+60 spmb=1.11111e+15 spomb=0 spomb1=1.11111e+60
    M32 (net1 VOSP net3 VSS) nch_ulvt_mac l=30n w=500n multi=1 nf=1 \
        sd=100n ad=3.75e-14 as=3.75e-14 pd=1.15u ps=1.15u nrd=0.662935 \
        nrs=0.662935 sa=75.0n sb=75.0n sa1=75.0n sa2=75.0n sa3=75.0n \
        sa4=75.0n sb1=75.0n sb2=75.0n sb3=75.0n spa=100n spa1=100n \
        spa2=100n spa3=100n sap=91.9776n sapb=114.444n spba=115.715n \
        spba1=117.043n dfm_flag=0 spmt=1.11111e+15 spomt=0 \
        spomt1=1.11111e+60 spmb=1.11111e+15 spomb=0 spomb1=1.11111e+60
    M10 (net7 VMP VSS VSS) nch_ulvt_mac l=30n w=500n multi=1 nf=1 sd=100n \
        ad=3.75e-14 as=3.75e-14 pd=1.15u ps=1.15u nrd=0.662935 \
        nrs=0.662935 sa=75.0n sb=75.0n sa1=75.0n sa2=75.0n sa3=75.0n \
        sa4=75.0n sb1=75.0n sb2=75.0n sb3=75.0n spa=100n spa1=100n \
        spa2=100n spa3=100n sap=91.9776n sapb=114.444n spba=115.715n \
        spba1=117.043n dfm_flag=0 spmt=1.11111e+15 spomt=0 \
        spomt1=1.11111e+60 spmb=1.11111e+15 spomb=0 spomb1=1.11111e+60
    M9 (VMN VMP net8 VSS) nch_ulvt_mac l=30n w=1u multi=1 nf=2 sd=100n \
        ad=5e-14 as=7.5e-14 pd=1.2u ps=2.3u nrd=0.425847 nrs=0.425847 \
        sa=112.742n sb=112.742n sa1=93.6047n sa2=112.078n sa3=163.715n \
        sa4=110.059n sb1=93.6047n sb2=112.078n sb3=163.715n spa=100n \
        spa1=100n spa2=100n spa3=100n sap=104.359n sapb=125.813n \
        spba=115.715n spba1=117.043n dfm_flag=0 spmt=1.11111e+15 spomt=0 \
        spomt1=1.11111e+60 spmb=1.11111e+15 spomb=0 spomb1=1.11111e+60
    M8 (VMP VMN net8 VSS) nch_ulvt_mac l=30n w=1u multi=1 nf=2 sd=100n \
        ad=5e-14 as=7.5e-14 pd=1.2u ps=2.3u nrd=0.425847 nrs=0.425847 \
        sa=112.742n sb=112.742n sa1=93.6047n sa2=112.078n sa3=163.715n \
        sa4=110.059n sb1=93.6047n sb2=112.078n sb3=163.715n spa=100n \
        spa1=100n spa2=100n spa3=100n sap=104.359n sapb=125.813n \
        spba=115.715n spba1=117.043n dfm_flag=0 spmt=1.11111e+15 spomt=0 \
        spomt1=1.11111e+60 spmb=1.11111e+15 spomb=0 spomb1=1.11111e+60
    M68 (VDD VDD net4 VSS) nch_ulvt_mac l=30n w=250.0n multi=1 nf=1 \
        sd=100n ad=1.875e-14 as=1.875e-14 pd=650.0n ps=650.0n nrd=1.338763 \
        nrs=1.338763 sa=75.0n sb=75.0n sa1=75.0n sa2=75.0n sa3=75.0n \
        sa4=75.0n sb1=75.0n sb2=75.0n sb3=75.0n spa=100n spa1=100n \
        spa2=100n spa3=100n sap=91.9776n sapb=114.444n spba=115.715n \
        spba1=117.043n dfm_flag=0 spmt=1.11111e+15 spomt=0 \
        spomt1=1.11111e+60 spmb=1.11111e+15 spomb=0 spomb1=1.11111e+60
    M47 (VINN PHI1BSTN net6 VSS) nch_ulvt_mac l=30n w=500n multi=1 nf=1 \
        sd=100n ad=3.75e-14 as=3.75e-14 pd=1.15u ps=1.15u nrd=0.662935 \
        nrs=0.662935 sa=75.0n sb=75.0n sa1=75.0n sa2=75.0n sa3=75.0n \
        sa4=75.0n sb1=75.0n sb2=75.0n sb3=75.0n spa=100n spa1=100n \
        spa2=100n spa3=100n sap=91.9776n sapb=114.444n spba=115.715n \
        spba1=117.043n dfm_flag=0 spmt=1.11111e+15 spomt=0 \
        spomt1=1.11111e+60 spmb=1.11111e+15 spomb=0 spomb1=1.11111e+60
    M33 (net4 VOSN net3 VSS) nch_ulvt_mac l=30n w=500n multi=1 nf=1 \
        sd=100n ad=3.75e-14 as=3.75e-14 pd=1.15u ps=1.15u nrd=0.662935 \
        nrs=0.662935 sa=75.0n sb=75.0n sa1=75.0n sa2=75.0n sa3=75.0n \
        sa4=75.0n sb1=75.0n sb2=75.0n sb3=75.0n spa=100n spa1=100n \
        spa2=100n spa3=100n sap=91.9776n sapb=114.444n spba=115.715n \
        spba1=117.043n dfm_flag=0 spmt=1.11111e+15 spomt=0 \
        spomt1=1.11111e+60 spmb=1.11111e+15 spomb=0 spomb1=1.11111e+60
    M55 (net10 PHI2P VSS VSS) nch_ulvt_mac l=30n w=2u multi=1 nf=4 sd=100n \
        ad=1e-13 as=1.25e-13 pd=2.4u ps=3.5u nrd=0.248269 nrs=0.248269 \
        sa=179.203n sb=179.203n sa1=118.069n sa2=174.76n sa3=310.76n \
        sa4=171.966n sb1=118.069n sb2=174.76n sb3=310.76n spa=100n \
        spa1=100n spa2=100n spa3=100n sap=120.952n sapb=140.537n \
        spba=115.715n spba1=117.043n dfm_flag=0 spmt=1.11111e+15 spomt=0 \
        spomt1=1.11111e+60 spmb=1.11111e+15 spomb=0 spomb1=1.11111e+60
    M78 (net4 VINN0 net3 VSS) nch_ulvt_mac l=30n w=4u multi=1 nf=8 sd=100n \
        ad=2e-13 as=2.25e-13 pd=4.8u ps=5.9u nrd=0.135370 nrs=0.135370 \
        sa=295.835n sb=295.835n sa1=149.315n sa2=274.565n sa3=507.343n \
        sa4=281.096n sb1=149.315n sb2=274.565n sb3=507.343n spa=100n \
        spa1=100n spa2=100n spa3=100n sap=142.36n sapb=158.808n \
        spba=115.715n spba1=117.043n dfm_flag=0 spmt=1.11111e+15 spomt=0 \
        spomt1=1.11111e+60 spmb=1.11111e+15 spomb=0 spomb1=1.11111e+60
    M36 (VINP PHI1BSTP net11 VSS) nch_ulvt_mac l=30n w=500n multi=1 nf=1 \
        sd=100n ad=3.75e-14 as=3.75e-14 pd=1.15u ps=1.15u nrd=0.662935 \
        nrs=0.662935 sa=75.0n sb=75.0n sa1=75.0n sa2=75.0n sa3=75.0n \
        sa4=75.0n sb1=75.0n sb2=75.0n sb3=75.0n spa=100n spa1=100n \
        spa2=100n spa3=100n sap=91.9776n sapb=114.444n spba=115.715n \
        spba1=117.043n dfm_flag=0 spmt=1.11111e+15 spomt=0 \
        spomt1=1.11111e+60 spmb=1.11111e+15 spomb=0 spomb1=1.11111e+60
    M77 (net1 VINP0 net3 VSS) nch_ulvt_mac l=30n w=4u multi=1 nf=8 sd=100n \
        ad=2e-13 as=2.25e-13 pd=4.8u ps=5.9u nrd=0.135370 nrs=0.135370 \
        sa=295.835n sb=295.835n sa1=149.315n sa2=274.565n sa3=507.343n \
        sa4=281.096n sb1=149.315n sb2=274.565n sb3=507.343n spa=100n \
        spa1=100n spa2=100n spa3=100n sap=142.36n sapb=158.808n \
        spba=115.715n spba1=117.043n dfm_flag=0 spmt=1.11111e+15 spomt=0 \
        spomt1=1.11111e+60 spmb=1.11111e+15 spomb=0 spomb1=1.11111e+60
    M41 (net8 PHI1EN VSS VSS) nch_ulvt_mac l=30n w=2u multi=1 nf=4 sd=100n \
        ad=1e-13 as=1.25e-13 pd=2.4u ps=3.5u nrd=0.248269 nrs=0.248269 \
        sa=179.203n sb=179.203n sa1=118.069n sa2=174.76n sa3=310.76n \
        sa4=171.966n sb1=118.069n sb2=174.76n sb3=310.76n spa=100n \
        spa1=100n spa2=100n spa3=100n sap=120.952n sapb=140.537n \
        spba=115.715n spba1=117.043n dfm_flag=0 spmt=1.11111e+15 spomt=0 \
        spomt1=1.11111e+60 spmb=1.11111e+15 spomb=0 spomb1=1.11111e+60
    M42 (DN net9 net10 VSS) nch_ulvt_mac l=30n w=2u multi=1 nf=4 sd=100n \
        ad=1e-13 as=1.25e-13 pd=2.4u ps=3.5u nrd=0.248269 nrs=0.248269 \
        sa=179.203n sb=179.203n sa1=118.069n sa2=174.76n sa3=310.76n \
        sa4=171.966n sb1=118.069n sb2=174.76n sb3=310.76n spa=100n \
        spa1=100n spa2=100n spa3=100n sap=120.952n sapb=140.537n \
        spba=115.715n spba1=117.043n dfm_flag=0 spmt=1.11111e+15 spomt=0 \
        spomt1=1.11111e+60 spmb=1.11111e+15 spomb=0 spomb1=1.11111e+60
    M43 (DP net7 net10 VSS) nch_ulvt_mac l=30n w=2u multi=1 nf=4 sd=100n \
        ad=1e-13 as=1.25e-13 pd=2.4u ps=3.5u nrd=0.248269 nrs=0.248269 \
        sa=179.203n sb=179.203n sa1=118.069n sa2=174.76n sa3=310.76n \
        sa4=171.966n sb1=118.069n sb2=174.76n sb3=310.76n spa=100n \
        spa1=100n spa2=100n spa3=100n sap=120.952n sapb=140.537n \
        spba=115.715n spba1=117.043n dfm_flag=0 spmt=1.11111e+15 spomt=0 \
        spomt1=1.11111e+60 spmb=1.11111e+15 spomb=0 spomb1=1.11111e+60
    M44 (net10 PHI2P VSS VSS) nch_ulvt_mac l=30n w=2u multi=1 nf=4 sd=100n \
        ad=1e-13 as=1.25e-13 pd=2.4u ps=3.5u nrd=0.248269 nrs=0.248269 \
        sa=179.203n sb=179.203n sa1=118.069n sa2=174.76n sa3=310.76n \
        sa4=171.966n sb1=118.069n sb2=174.76n sb3=310.76n spa=100n \
        spa1=100n spa2=100n spa3=100n sap=120.952n sapb=140.537n \
        spba=115.715n spba1=117.043n dfm_flag=0 spmt=1.11111e+15 spomt=0 \
        spomt1=1.11111e+60 spmb=1.11111e+15 spomb=0 spomb1=1.11111e+60
    M63 (VDD VDD net1 VSS) nch_ulvt_mac l=30n w=250.0n multi=1 nf=1 \
        sd=100n ad=1.875e-14 as=1.875e-14 pd=650.0n ps=650.0n nrd=1.338763 \
        nrs=1.338763 sa=75.0n sb=75.0n sa1=75.0n sa2=75.0n sa3=75.0n \
        sa4=75.0n sb1=75.0n sb2=75.0n sb3=75.0n spa=100n spa1=100n \
        spa2=100n spa3=100n sap=91.9776n sapb=114.444n spba=115.715n \
        spba1=117.043n dfm_flag=0 spmt=1.11111e+15 spomt=0 \
        spomt1=1.11111e+60 spmb=1.11111e+15 spomb=0 spomb1=1.11111e+60
// @RNL(author="rnl-virtuoso") {
//   %block_symbol = @DEFINE-SYMBOL(box=[-14, -10, 16, 10]) {
//     @LINE {(0, 12) (0, 8)};
//     @LINE {(2, 12) (2, 8)};
//     @LINE {(18, 0) (14, 0)};
//     @LINE {(-16, 0) (-12, 0)};
//     @LINE {(4, 12) (4, 8)};
//     @LINE {(-4, 12) (-4, 8)};
//     @LINE {(-2, 12) (-2, 8)};
//     @LINE {(-12, 8) (14, 8) (14, -8) (-12, -8) (-12, 8)};
//     @LINE {(-1.7, 3) (-1.7, -3) (3.3, 0) (-1.7, 3)};
//     @LINE {(-0.5, 0) (0.5, 0)};
//     @LINE {(0.5, 1) (0, 1) (0, -1) (-0.5, -1)};
//     @LINE {(-6, 12) (-6, 8)};
//     @LINE {(1, -12) (1, -8)};
//     @LINE {(-1, -12) (-1, -8)};
//     @LINE {(-3, -12) (-3, -8)};
//     @LINE {(3, -12) (3, -8)};
//     @LINE {(18, -2) (14, -2)};
//     @LINE {(18, 2) (14, 2)};
//     @LINE {(-16, -2) (-12, -2)};
//     @LINE {(-16, -4) (-12, -4)};
//     @LINE {(8, 12) (8, 8)};
//     @LINE {(6, 12) (6, 8)};
//     @LINE {(-16, 2) (-12, 2)};
//     @LINE {(-16, 4) (-12, 4)};
//     ? @TEXT("${model}", size=1, halign="start", valign="middle", key="model") => @PLACE(12, 7);
//     ? @TEXT("${name}", size=1, halign="start", valign="middle", key="name") => @PLACE(12, 9);
//     (2, 12) @PIN(terminal="PHI1EPBST");
//     (2, 7.4) @TEXT("PHI1EPBST", size=1, halign="end", valign="middle", rotate=90);
//     (18, 0) @PIN(terminal="DN");
//     (13.4, 0) @TEXT("DN", size=1, halign="end", valign="middle");
//     (18, 2) @PIN(terminal="DP");
//     (13.4, 2) @TEXT("DP", size=1, halign="end", valign="middle");
//     (-16, -4) @PIN(terminal="VB");
//     (-11.4, -4) @TEXT("VB", size=1, halign="start", valign="middle");
//     (-16, 4) @PIN(terminal="VINP");
//     (-11.4, 4) @TEXT("VINP", size=1, halign="start", valign="middle");
//     (-16, 2) @PIN(terminal="VINN");
//     (-11.4, 2) @TEXT("VINN", size=1, halign="start", valign="middle");
//     (1, -12) @PIN(terminal="VDD");
//     (1, -7.4) @TEXT("VDD", size=1, halign="start", valign="middle", rotate=90);
//     (3, -12) @PIN(terminal="VSS");
//     (3, -7.4) @TEXT("VSS", size=1, halign="start", valign="middle", rotate=90);
//     (-16, 0) @PIN(terminal="VOSP");
//     (-11.4, 0) @TEXT("VOSP", size=1, halign="start", valign="middle");
//     (-6, 12) @PIN(terminal="VCM");
//     (-6, 7.4) @TEXT("VCM", size=1, halign="end", valign="middle", rotate=90);
//     (-1, -12) @PIN(terminal="VREFN");
//     (-1, -7.4) @TEXT("VREFN", size=1, halign="start", valign="middle", rotate=90);
//     (-3, -12) @PIN(terminal="VREFP");
//     (-3, -7.4) @TEXT("VREFP", size=1, halign="start", valign="middle", rotate=90);
//     (-2, 12) @PIN(terminal="PHI1BSTN");
//     (-2, 7.4) @TEXT("PHI1BSTN", size=1, halign="end", valign="middle", rotate=90);
//     (-4, 12) @PIN(terminal="PHI1BSTP");
//     (-4, 7.4) @TEXT("PHI1BSTP", size=1, halign="end", valign="middle", rotate=90);
//     (4, 12) @PIN(terminal="PHI1EN");
//     (4, 7.4) @TEXT("PHI1EN", size=1, halign="end", valign="middle", rotate=90);
//     (18, -2) @PIN(terminal="D");
//     (13.4, -2) @TEXT("D", size=1, halign="end", valign="middle");
//     (8, 12) @PIN(terminal="PHI2N");
//     (8, 7.4) @TEXT("PHI2N", size=1, halign="end", valign="middle", rotate=90);
//     (6, 12) @PIN(terminal="PHI2P");
//     (6, 7.4) @TEXT("PHI2P", size=1, halign="end", valign="middle", rotate=90);
//     (-16, -2) @PIN(terminal="VOSN");
//     (-11.4, -2) @TEXT("VOSN", size=1, halign="start", valign="middle");
//     (0, 12) @PIN(terminal="PHI1EP");
//     (0, 7.4) @TEXT("PHI1EP", size=1, halign="end", valign="middle", rotate=90)
//   };
//   # @SET-SYMBOL %block_symbol;
//   %symbol_0 = @DEFINE-SYMBOL(box=[-0.1, -2.8, 3.8, 2.8]) {
//     @LINE {(2, 1.5) (4, 1.5) (4, 3)};
//     @LINE {(2, -1.5) (2, 1.5)};
//     @LINE {(3, -1) (4, -1.5) (3, -2)};
//     @LINE {(0, 0) (1.5, 0)};
//     @LINE {(1.5, 1.5) (1.5, -1.5)};
//     @LINE {(2, -1.5) (4, -1.5) (4, -3)};
//     ? @TEXT("${name}", size=0.8, halign="start", valign="baseline", key="name") => @PLACE(5, 3.5);
//     ? @TEXT("${model}", size=0.8, halign="end", valign="baseline", key="model") => @PLACE(3.2, 3.2);
//     (4, -1) @PIN(terminal=4);
//     (4, -3) @PIN(terminal=3);
//     (4, 3) @PIN(terminal=1);
//     (0, 0) @PIN(terminal=2)
//   };
//   #"M1" @SET-SYMBOL %symbol_0;
//   #"M1" @PLACE(56, -36) => @ORIENT("R270");
//   %symbol_1 = @DEFINE-SYMBOL(box=[-0.1, -2.8, 3.8, 2.8]) {
//     @LINE {(0, 0) (0.7, 0)};
//     @LINE {(1.5, 1.5) (1.5, -1.5)};
//     @LINE {(2, -1.5) (4, -1.5) (4, -3)};
//     @LINE {(2, 1.5) (4, 1.5) (4, 3)};
//     (1.1, 0) @CIRCLE(radius=0.4);
//     @LINE {(3.7, 2) (2.7, 1.5) (3.7, 1)};
//     @LINE {(2, -1.5) (2, 1.5)};
//     ? @TEXT("${name}", size=0.8, halign="start", valign="baseline", key="name") => @PLACE(4.9, 3.4);
//     ? @TEXT("${model}", size=0.8, halign="end", valign="baseline", key="model") => @PLACE(3.3, 3.2);
//     (4, 3) @PIN(terminal=3);
//     (4, 1) @PIN(terminal=4);
//     (0, 0) @PIN(terminal=2);
//     (4, -3) @PIN(terminal=1)
//   };
//   #"M21" @SET-SYMBOL %symbol_1;
//   #"M21" @PLACE(100, 72) => @ORIENT("R0");
//   %symbol_2 = @DEFINE-SYMBOL(box=[0, -2, 12, 2]) {
//     @LINE {(0, 0) (3.5, 0)};
//     @LINE {(3.5, 2.8) (3.5, -3.2)};
//     @LINE {(8.5, 2.8) (8.5, -3.2)};
//     @LINE {(12, 0) (8.5, 0)};
//     @LINE {(3.5, 2.8) (8.5, 0)};
//     @LINE {(3.5, -3.2) (8.5, 0)};
//     @LINE {(8.5, 2.8) (3.5, 0)};
//     @LINE {(3.5, 0) (8.5, -3.2)};
//     @LINE {(6, -1.6) (6, -3.2)};
//     @LINE {(6, 2.6) (6, 1.8)};
//     @ARC {(6, 1.2) (6.3, 1.5) (6, 1.8)};
//     @ARC {(6, 1.8) (5.7, 1.5) (6, 1.2)};
//     (-0.4, 0.6) @TEXT("A", size=0.5, halign="start", valign="baseline");
//     (11.6, 0.6) @TEXT("Y", size=0.5, halign="start", valign="baseline");
//     (5.6, 3.6) @TEXT("CB", size=0.5, halign="start", valign="baseline");
//     (5.6, -2.4) @TEXT("C", size=0.5, halign="start", valign="baseline");
//     (3.6, 3.6) @TEXT("Pb", size=0.5, halign="start", valign="baseline");
//     (3.6, -2.4) @TEXT("Gb", size=0.5, halign="start", valign="baseline");
//     (6, 0) @TEXT("S", size=1.6, halign="middle", valign="middle");
//     ? @TEXT("${name}", size=0.8, halign="end", valign="baseline", key="name") => @PLACE(12, 4);
//     (0, 0) @PIN(terminal=1);
//     (12, 0) @PIN(terminal=6);
//     (6, 3) @PIN(terminal=3);
//     (6, -3) @PIN(terminal=2);
//     (4, 3) @PIN(terminal=5);
//     (4, -3) @PIN(terminal=4)
//   };
//   #"I7" @SET-SYMBOL %symbol_2;
//   #"I7" @PLACE(16, -18) => @ORIENT("MXR90");
//   %symbol_3 = @DEFINE-SYMBOL(box=[-0.1, -2.8, 3.8, 2.8]) {
//     @LINE {(2, 1.5) (4, 1.5) (4, 3)};
//     @LINE {(2, -1.5) (2, 1.5)};
//     @LINE {(3, -1) (4, -1.5) (3, -2)};
//     @LINE {(0, 0) (1.5, 0)};
//     @LINE {(1.5, 1.5) (1.5, -1.5)};
//     @LINE {(2, -1.5) (4, -1.5) (4, -3)};
//     ? @TEXT("${name}", size=0.8, halign="start", valign="baseline", key="name") => @PLACE(5, 3.5);
//     ? @TEXT("${model}", size=0.8, halign="end", valign="baseline", key="model") => @PLACE(3.2, 3.2);
//     (4, -1) @PIN(terminal=4);
//     (4, -3) @PIN(terminal=3);
//     (4, 3) @PIN(terminal=1);
//     (0, 0) @PIN(terminal=2)
//   };
//   #"M55" @SET-SYMBOL %symbol_3;
//   #"M55" @PLACE(4, 48) => @ORIENT("R0");
//   #"M37" @SET-SYMBOL %symbol_1;
//   #"M37" @PLACE(132, 72) => @ORIENT("R0");
//   #"M10" @SET-SYMBOL %symbol_3;
//   #"M10" @PLACE(100, 56) => @ORIENT("R0");
//   #"I3" @SET-SYMBOL %symbol_2;
//   #"I3" @PLACE(0, -18) => @ORIENT("R90");
//   #"M22" @SET-SYMBOL %symbol_1;
//   #"M22" @PLACE(28, 72) => @ORIENT("MY");
//   #"I8" @SET-SYMBOL %symbol_2;
//   #"I8" @PLACE(112, -18) => @ORIENT("R90");
//   #"M43" @SET-SYMBOL %symbol_3;
//   #"M43" @PLACE(116, 56) => @ORIENT("R0");
//   #"M33" @SET-SYMBOL %symbol_3;
//   #"M33" @PLACE(92, -8) => @ORIENT("MY");
//   #"M62" @SET-SYMBOL %symbol_3;
//   #"M62" @PLACE(64, 12) => @ORIENT("MYR90");
//   %symbol_4 = @DEFINE-SYMBOL(box=[-2, -6, 2, 0]) {
//     @LINE {(1, -2.2) (-1, -2.2)};
//     @LINE {(0, 0) (0, -2.2)};
//     @LINE {(0, -2.8) (0, -6)};
//     @ARC {(1, -3.2) (0, -2.8) (-1, -3.2)};
//     ? @TEXT("${name}", size=0.8, halign="start", valign="baseline", key="name") => @PLACE(1.4, 0.1);
//     ? @TEXT("${model}", size=0.8, halign="end", valign="baseline", key="model") => @PLACE(-1.1, 0.3);
//     (0, 0) @PIN(terminal=1);
//     (0, -6) @PIN(terminal=2)
//   };
//   #"C3" @SET-SYMBOL %symbol_4;
//   #"C3" @PLACE(5, 0) => @ORIENT("R90");
//   #"M23" @SET-SYMBOL %symbol_3;
//   #"M23" @PLACE(28, 56) => @ORIENT("MY");
//   #"M0" @SET-SYMBOL %symbol_0;
//   #"M0" @PLACE(60, -24) => @ORIENT("R0");
//   #"M31" @SET-SYMBOL %symbol_1;
//   #"M31" @PLACE(-4, 72) => @ORIENT("MY");
//   #"M9" @SET-SYMBOL %symbol_3;
//   #"M9" @PLACE(56, 56) => @ORIENT("MY");
//   #"M36" @SET-SYMBOL %symbol_3;
//   #"M36" @PLACE(-16, 4) => @ORIENT("MYR90");
//   #"I5" @SET-SYMBOL %symbol_2;
//   #"I5" @PLACE(128, -18) => @ORIENT("MXR90");
//   #"M41" @SET-SYMBOL %symbol_3;
//   #"M41" @PLACE(60, 40) => @ORIENT("R0");
//   %symbol_5 = @DEFINE-SYMBOL(box=[-3, -4, 6, 4]) {
//     @LINE {(-1, -2) (1, -2)};
//     @LINE {(-1, 2) (1, 2)};
//     @LINE {(-3, 1) (-1, 1)};
//     @ARC {(1, -2) (3, 0) (1, 2)};
//     @LINE {(5, 0) (6, 0)};
//     @LINE {(-3, -1) (-1, -1)};
//     (3.5, 0) @CIRCLE(radius=0.5);
//     @LINE {(-1, 2) (-1, -2)};
//     @LINE {(0, -4) (0, -2)};
//     @LINE {(4, 0) (5, 0)};
//     @LINE {(0, 4) (0, 2)};
//     ? @TEXT("${model}", size=0.4, halign="end", valign="baseline", key="model") => @PLACE(6, -4);
//     ? @TEXT("${name}", size=0.4, halign="end", valign="top", key="name") => @PLACE(6, 4);
//     (0, -4) @PIN(terminal=4);
//     (0.9, -4) @TEXT("VSS", size=0.4, halign="start", valign="middle");
//     (6, 0) @PIN(terminal=5);
//     (2.6, 0) @TEXT("ZN", size=0.4, halign="end", valign="middle");
//     (-3, 1) @PIN(terminal=1);
//     (-0.6, 1) @TEXT("A1", size=0.4, halign="start", valign="middle");
//     (-3, -1) @PIN(terminal=2);
//     (-0.6, -1) @TEXT("A2", size=0.4, halign="start", valign="middle");
//     (0, 4) @PIN(terminal=3);
//     (0.9, 4) @TEXT("VDD", size=0.4, halign="start", valign="middle")
//   };
//   #"I13" @SET-SYMBOL %symbol_5;
//   #"I13" @PLACE(176, 48) => @ORIENT("MX");
//   #"M68" @SET-SYMBOL %symbol_3;
//   #"M68" @PLACE(80, 18) => @ORIENT("MY");
//   #"M42" @SET-SYMBOL %symbol_3;
//   #"M42" @PLACE(12, 56) => @ORIENT("MY");
//   #"M77" @SET-SYMBOL %symbol_3;
//   #"M77" @PLACE(48, 0) => @ORIENT("R0");
//   #"M78" @SET-SYMBOL %symbol_3;
//   #"M78" @PLACE(80, 0) => @ORIENT("MY");
//   #"M47" @SET-SYMBOL %symbol_3;
//   #"M47" @PLACE(144, 4) => @ORIENT("R270");
//   #"I16" @SET-SYMBOL %symbol_5;
//   #"I16" @PLACE(176, 32) => @ORIENT("R0");
//   #"C4" @SET-SYMBOL %symbol_4;
//   #"C4" @PLACE(123, 0) => @ORIENT("MXR90");
//   #"M87" @SET-SYMBOL %symbol_1;
//   #"M87" @PLACE(72, 72) => @ORIENT("R0");
//   #"M8" @SET-SYMBOL %symbol_3;
//   #"M8" @PLACE(72, 56) => @ORIENT("R0");
//   #"M57" @SET-SYMBOL %symbol_3;
//   #"M57" @PLACE(84, 40) => @ORIENT("R0");
//   #"M56" @SET-SYMBOL %symbol_3;
//   #"M56" @PLACE(36, 40) => @ORIENT("R0");
//   #"M12" @SET-SYMBOL %symbol_1;
//   #"M12" @PLACE(56, 72) => @ORIENT("MY");
//   #"M30" @SET-SYMBOL %symbol_1;
//   #"M30" @PLACE(12, 72) => @ORIENT("MY");
//   #"M63" @SET-SYMBOL %symbol_3;
//   #"M63" @PLACE(48, 18) => @ORIENT("R0");
//   #"M38" @SET-SYMBOL %symbol_1;
//   #"M38" @PLACE(116, 72) => @ORIENT("R0");
//   #"M44" @SET-SYMBOL %symbol_3;
//   #"M44" @PLACE(124, 48) => @ORIENT("MY");
//   #"M58" @SET-SYMBOL %symbol_1;
//   #"M58" @PLACE(60, 88) => @ORIENT("R0");
//   #"M32" @SET-SYMBOL %symbol_3;
//   #"M32" @PLACE(36, -8) => @ORIENT("R0");
//   %input_port_symbol = @DEFINE-SYMBOL(box=[-2, -1, 0, 1]) {
//       @LINE(fill="linecolor", linestyle="none") {(-2, -0.9) (-2, 0.9) (-0.9, 0.9) (0, 0) (-0.9, -0.9) (-2, -0.9)};
//       (0, 0) @PIN(terminal=1, direction="right");
//       ? @TEXT("${name}", key="name", halign="middle") => @PLACE(-1, 1.6)
//     };
//   %port_0 = $IO_PORT @ATTACH &"VOSP" => @PLACE(32, -8) => @ORIENT("R0");
//   %port_0 @SET-SYMBOL %input_port_symbol;
//   %port_0 @TEXT("VOSP", key="name");
//   %output_port_symbol = @DEFINE-SYMBOL(box=[0, -1, 2, 1]) {
//       @LINE(fill="linecolor", linestyle="none") {(0, -0.9) (0, 0.9) (1.1, 0.9) (2, 0) (1.1, -0.9) (0, -0.9)};
//       (0, 0) @PIN(terminal=1, direction="left");
//       ? @TEXT("${name}", key="name", halign="middle") => @PLACE(1, 1.6)
//     };
//   %port_1 = $IO_PORT @ATTACH &"DP" => @PLACE(142, 64) => @ORIENT("R0");
//   %port_1 @SET-SYMBOL %output_port_symbol;
//   %port_1 @TEXT("DP", key="name");
//   %port_2 = $IO_PORT @ATTACH &"VCM" => @PLACE(112, -25) => @ORIENT("MXR90");
//   %port_3 = $IO_PORT @ATTACH &"VCM" => @PLACE(16, -25) => @ORIENT("R90");
//   %port_4 = $IO_PORT @ATTACH &"VINP" => @PLACE(-26, 0) => @ORIENT("R0");
//   %port_4 @SET-SYMBOL %input_port_symbol;
//   %port_4 @TEXT("VINP", key="name");
//   %port_5 = $IO_PORT @ATTACH &"DN" => @PLACE(-14, 64) => @ORIENT("R180");
//   %port_5 @SET-SYMBOL %output_port_symbol;
//   %port_5 @TEXT("DN", key="name");
//   %port_6 = $IO_PORT @ATTACH &"VDD" => @PLACE(-49, 36) => @ORIENT("R0");
//   %port_7 = $IO_PORT @ATTACH &"VSS" => @PLACE(-49, 32) => @ORIENT("R0");
//   %port_8 = $IO_PORT @ATTACH &"VREFN" => @PLACE(128, -25) => @ORIENT("MXR90");
//   %port_9 = $IO_PORT @ATTACH &"PHI1EPBST" => @PLACE(-48, 24) => @ORIENT("R0");
//   %port_9 @SET-SYMBOL %input_port_symbol;
//   %port_9 @TEXT("PHI1EPBST", key="name");
//   %port_10 = $IO_PORT @ATTACH &"PHI1EN" => @PLACE(-48, 40) => @ORIENT("R0");
//   %port_10 @SET-SYMBOL %input_port_symbol;
//   %port_10 @TEXT("PHI1EN", key="name");
//   %port_11 = $IO_PORT @ATTACH &"PHI1BSTN" => @PLACE(144, 10) => @ORIENT("R270");
//   %port_11 @SET-SYMBOL %input_port_symbol;
//   %port_11 @TEXT("PHI1BSTN", key="name");
//   %port_12 = $IO_PORT @ATTACH &"PHI2P" => @PLACE(-48, 48) => @ORIENT("R0");
//   %port_12 @SET-SYMBOL %input_port_symbol;
//   %port_12 @TEXT("PHI2P", key="name");
//   %port_13 = $IO_PORT @ATTACH &"PHI2N" => @PLACE(-48, 44) => @ORIENT("R0");
//   %port_13 @SET-SYMBOL %input_port_symbol;
//   %port_13 @TEXT("PHI2N", key="name");
//   %port_14 = $IO_PORT @ATTACH &"PHI1BSTP" => @PLACE(-16, 8) => @ORIENT("R270");
//   %port_14 @SET-SYMBOL %input_port_symbol;
//   %port_14 @TEXT("PHI1BSTP", key="name");
//   %port_15 = $IO_PORT @ATTACH &"VREFP" => @PLACE(0, -25) => @ORIENT("R90");
//   %port_16 = $IO_PORT @ATTACH &"VINN" => @PLACE(154, 0) => @ORIENT("MY");
//   %port_16 @SET-SYMBOL %input_port_symbol;
//   %port_16 @TEXT("VINN", key="name");
//   %port_17 = $IO_PORT @ATTACH &"VB" => @PLACE(48, -24) => @ORIENT("R0");
//   %port_17 @SET-SYMBOL %input_port_symbol;
//   %port_17 @TEXT("VB", key="name");
//   %port_18 = $IO_PORT @ATTACH &"VOSN" => @PLACE(96, -8) => @ORIENT("MY");
//   %port_18 @SET-SYMBOL %input_port_symbol;
//   %port_18 @TEXT("VOSN", key="name");
//   %port_19 = $IO_PORT @ATTACH &"D" => @PLACE(190, 32) => @ORIENT("R0");
//   %port_19 @SET-SYMBOL %output_port_symbol;
//   %port_19 @TEXT("D", key="name");
//   %port_20 = $IO_PORT @ATTACH &"PHI1EP" => @PLACE(-48, 28) => @ORIENT("R0");
//   %port_20 @SET-SYMBOL %input_port_symbol;
//   %port_20 @TEXT("PHI1EP", key="name");
//   %p0 = (52, 9);
//   %wire_0 = &"net1" @WIRE(mode="straight") {#"M77":1 %p0};
//   %wire_1 = &"net1" @WIRE(mode="straight") {%p0 #"M63":3};
//   %p1 = (40, 8);
//   %p2 = (51, 8);
//   %wire_2 = &"net1" @WIRE(mode="straight") {%p1 %p2};
//   %wire_3 = &"net1" @WIRE(mode="straight") {#"M32":1 %p1};
//   %wire_4 = &"net1" @WIRE(mode="straight") {%p2 #"M62":1};
//   %p3 = (51, 9);
//   %wire_5 = &"net1" @WIRE(mode="straight") {%p3 %p0};
//   %wire_6 = &"net1" @WIRE(mode="straight") {%p1 #"M56":3};
//   %wire_7 = &"net1" @WIRE(mode="straight") {%p2 %p3};
//   %p4 = (170, 33);
//   %p5 = (170, 36);
//   %wire_8 = &"net15" @WIRE(mode="straight") {%p4 %p5};
//   %wire_9 = &"net15" @WIRE(mode="straight") {%p4 #"I16":1};
//   %p6 = (184, 44);
//   %wire_10 = &"net15" @WIRE(mode="straight") {%p5 %p6};
//   %p7 = (184, 48);
//   %wire_11 = &"net15" @WIRE(mode="straight") {#"I13":5 %p7};
//   %wire_12 = &"net15" @WIRE(mode="straight") {%p6 %p7};
//   %wire_13 = &"VOSP" @WIRE(mode="straight") {%port_0:p #"M32":2};
//   %p8 = (52, -16);
//   %wire_14 = &"net3" @WIRE(mode="straight") {%p8 #"M77":3};
//   %p9 = (40, -16);
//   %wire_15 = &"net3" @WIRE(mode="straight") {%p9 #"M32":3};
//   %p10 = (64, -16);
//   %wire_16 = &"net3" @WIRE(mode="straight") {%p8 %p10};
//   %p11 = (88, -16);
//   %wire_17 = &"net3" @WIRE(mode="straight") {%p11 #"M33":3};
//   %p12 = (76, -16);
//   %wire_18 = &"net3" @WIRE(mode="straight") {%p10 %p12};
//   %wire_19 = &"net3" @WIRE(mode="straight") {%p12 %p11};
//   %wire_20 = &"net3" @WIRE(mode="straight") {#"M0":1 %p10};
//   %wire_21 = &"net3" @WIRE(mode="straight") {%p9 %p8};
//   %wire_22 = &"net3" @WIRE(mode="straight") {%p12 #"M78":3};
//   %p13 = (31, 64);
//   %p14 = (31, 72);
//   %wire_23 = &"VMN" @WIRE(mode="straight") {%p13 %p14};
//   %p15 = (40, 64);
//   %wire_24 = &"VMN" @WIRE(mode="straight") {#"M56":1 %p15};
//   %p16 = (70, 65);
//   %p17 = (70, 72);
//   %wire_25 = &"VMN" @WIRE(mode="straight") {%p16 %p17};
//   %p18 = (31, 56);
//   %wire_26 = &"VMN" @WIRE(mode="straight") {%p18 %p13};
//   %p19 = (52, 64);
//   %wire_27 = &"VMN" @WIRE(mode="straight") {%p15 %p19};
//   %wire_28 = &"VMN" @WIRE(mode="straight") {%p13 %p15};
//   %p20 = (65, 65);
//   %wire_29 = &"VMN" @WIRE(mode="straight") {%p20 %p16};
//   %p21 = (70, 56);
//   %wire_30 = &"VMN" @WIRE(mode="straight") {%p21 #"M8":2};
//   %p22 = (63, 63);
//   %wire_31 = &"VMN" @WIRE(mode="straight") {%p22 %p20};
//   %wire_32 = &"VMN" @WIRE(mode="straight") {%p19 #"M12":1};
//   %wire_33 = &"VMN" @WIRE(mode="straight") {%p17 #"M87":2};
//   %p23 = (52, 63);
//   %wire_34 = &"VMN" @WIRE(mode="straight") {%p23 %p19};
//   %wire_35 = &"VMN" @WIRE(mode="straight") {%p23 %p22};
//   %wire_36 = &"VMN" @WIRE(mode="straight") {#"M9":1 %p23};
//   %wire_37 = &"VMN" @WIRE(mode="straight") {%p18 #"M23":2};
//   %wire_38 = &"VMN" @WIRE(mode="straight") {%p14 #"M22":2};
//   %wire_39 = &"VMN" @WIRE(mode="straight") {%p21 %p16};
//   %wire_27 @TEXT("VMN", size=1, halign="middle", valign="baseline") => @PLACE(42, 64.7);
//   %p24 = (128, 48);
//   %p25 = (128, 72);
//   %wire_40 = &"PHI2P" @WIRE(mode="straight") {%p24 %p25};
//   %wire_41 = &"PHI2P" @WIRE(mode="straight") {#"M37":2 %p25};
//   %wire_42 = &"PHI2P" @WIRE(mode="straight") {#"M44":2 %p24};
//   %p26 = (132, 48);
//   %wire_43 = &"PHI2P" @WIRE(mode="straight") {%p24 %p26};
//   %p27 = (0, 72);
//   %wire_44 = &"PHI2P" @WIRE(mode="straight") {#"M31":2 %p27};
//   %p28 = (0, 48);
//   %wire_45 = &"PHI2P" @WIRE(mode="straight") {%p28 %p27};
//   %wire_46 = &"PHI2P" @WIRE(mode="straight") {%p28 #"M55":2};
//   %wire_47 = &"PHI2P" @WIRE(mode="straight") {#"I3":2 #"I7":2};
//   %p29 = (-4, 48);
//   %wire_48 = &"PHI2P" @WIRE(mode="straight") {%p29 %p28};
//   %wire_49 = &"PHI2P" @WIRE(mode="straight") {#"I8":2 #"I5":2};
//   %wire_47 @TEXT("PHI2P", size=1, halign="middle", valign="baseline") => @PLACE(8, -11.3);
//   %wire_48 @TEXT("PHI2P", size=1, halign="middle", valign="baseline") => @PLACE(-3, 48.7);
//   %wire_43 @TEXT("PHI2P", size=1, halign="middle", valign="baseline") => @PLACE(131, 48.7);
//   %wire_49 @TEXT("PHI2P", size=1, halign="middle", valign="baseline") => @PLACE(120, -11.3);
//   %p30 = (0, -24);
//   %wire_50 = &"VREFP" @WIRE(mode="straight") {%p30 #"I3":1};
//   %p31 = (15, 56);
//   %p32 = (15, 64);
//   %wire_51 = &"net9" @WIRE(mode="straight") {%p31 %p32};
//   %wire_52 = &"net9" @WIRE(mode="straight") {#"M42":2 %p31};
//   %p33 = (24, 64);
//   %wire_53 = &"net9" @WIRE(mode="straight") {#"M23":1 %p33};
//   %wire_54 = &"net9" @WIRE(mode="straight") {%p32 %p33};
//   %p34 = (15, 72);
//   %wire_55 = &"net9" @WIRE(mode="straight") {#"M30":2 %p34};
//   %wire_56 = &"net9" @WIRE(mode="straight") {%p33 #"M22":1};
//   %wire_57 = &"net9" @WIRE(mode="straight") {%p32 %p34};
//   %p35 = (76, 80);
//   %p36 = (104, 80);
//   %wire_58 = &"net2" @WIRE(mode="straight") {%p35 %p36};
//   %p37 = (24, 80);
//   %p38 = (52, 80);
//   %wire_59 = &"net2" @WIRE(mode="straight") {%p37 %p38};
//   %p39 = (64, 80);
//   %wire_60 = &"net2" @WIRE(mode="straight") {%p39 %p35};
//   %wire_61 = &"net2" @WIRE(mode="straight") {#"M12":3 %p38};
//   %wire_62 = &"net2" @WIRE(mode="straight") {%p39 #"M58":1};
//   %wire_63 = &"net2" @WIRE(mode="straight") {#"M87":3 %p35};
//   %wire_64 = &"net2" @WIRE(mode="straight") {#"M22":3 %p37};
//   %wire_65 = &"net2" @WIRE(mode="straight") {#"M21":3 %p36};
//   %wire_66 = &"net2" @WIRE(mode="straight") {%p38 %p39};
//   %p40 = (169, 31);
//   %wire_67 = &"DN" @WIRE(mode="straight") {%p40 #"I16":2};
//   %p41 = (-16, 64);
//   %p42 = (-8, 64);
//   %wire_68 = &"DN" @WIRE(mode="straight") {%p41 %port_5:p %p42};
//   %wire_69 = &"DN" @WIRE(mode="straight") {%p42 #"M31":1};
//   %p43 = (8, 64);
//   %wire_70 = &"DN" @WIRE(mode="straight") {%p43 #"M30":1};
//   %wire_71 = &"DN" @WIRE(mode="straight") {%p42 %p43};
//   %wire_72 = &"DN" @WIRE(mode="straight") {#"M42":1 %p43};
//   %wire_67 @TEXT("DN", size=1, halign="middle", valign="baseline") => @PLACE(170, 31.7);
//   %p44 = (56, 40);
//   %wire_73 = &"PHI1EN" @WIRE(mode="straight") {%p44 #"M41":2};
//   %wire_73 @TEXT("PHI1EN", size=1, halign="middle", valign="baseline") => @PLACE(58, 40.7);
//   %p45 = (128, -24);
//   %wire_74 = &"VREFN" @WIRE(mode="straight") {%p45 #"I5":1};
//   %p46 = (170, 44);
//   %p47 = (170, 47);
//   %wire_75 = &"D" @WIRE(mode="straight") {%p46 %p47};
//   %wire_76 = &"D" @WIRE(mode="straight") {%p47 #"I13":1};
//   %p48 = (184, 36);
//   %wire_77 = &"D" @WIRE(mode="straight") {%p46 %p48};
//   %p49 = (184, 32);
//   %wire_78 = &"D" @WIRE(mode="straight") {#"I16":5 %p49};
//   %wire_79 = &"D" @WIRE(mode="straight") {%p49 %p48};
//   %wire_80 = &"D" @WIRE(mode="straight") {%p49 %port_19:p};
//   %p50 = (88, 64);
//   %p51 = (97, 64);
//   %wire_81 = &"VMP" @WIRE(mode="straight") {%p50 %p51};
//   %wire_82 = &"VMP" @WIRE(mode="straight") {#"M57":1 %p50};
//   %p52 = (97, 72);
//   %wire_83 = &"VMP" @WIRE(mode="straight") {%p51 %p52};
//   %p53 = (76, 64);
//   %wire_84 = &"VMP" @WIRE(mode="straight") {%p53 #"M87":1};
//   %p54 = (58, 65);
//   %p55 = (58, 72);
//   %wire_85 = &"VMP" @WIRE(mode="straight") {%p54 %p55};
//   %p56 = (97, 56);
//   %wire_86 = &"VMP" @WIRE(mode="straight") {%p56 #"M10":2};
//   %wire_87 = &"VMP" @WIRE(mode="straight") {%p52 #"M21":2};
//   %wire_88 = &"VMP" @WIRE(mode="straight") {%p53 %p50};
//   %wire_89 = &"VMP" @WIRE(mode="straight") {%p56 %p51};
//   %p57 = (76, 63);
//   %wire_90 = &"VMP" @WIRE(mode="straight") {%p57 %p53};
//   %p58 = (63, 65);
//   %p59 = (65, 63);
//   %wire_91 = &"VMP" @WIRE(mode="straight") {%p58 %p59};
//   %wire_92 = &"VMP" @WIRE(mode="straight") {%p54 %p58};
//   %p60 = (58, 56);
//   %wire_93 = &"VMP" @WIRE(mode="straight") {%p60 %p54};
//   %wire_94 = &"VMP" @WIRE(mode="straight") {%p59 %p57};
//   %wire_95 = &"VMP" @WIRE(mode="straight") {#"M12":2 %p55};
//   %wire_96 = &"VMP" @WIRE(mode="straight") {#"M8":1 %p57};
//   %wire_97 = &"VMP" @WIRE(mode="straight") {#"M9":2 %p60};
//   %wire_81 @TEXT("VMP", size=1, halign="middle", valign="baseline") => @PLACE(90, 64.7);
//   %wire_98 = &"VINN" @WIRE(mode="straight") {#"M47":1 %port_16:p};
//   %wire_99 = &"PHI1BSTP" @WIRE(mode="straight") {#"M36":2 %port_14:p};
//   %p61 = (0, 0);
//   %wire_100 = &"net11" @WIRE(mode="straight") {#"I3":6 %p61};
//   %wire_101 = &"net11" @WIRE(mode="straight") {%p61 #"C3":1};
//   %wire_102 = &"net11" @WIRE(mode="straight") {#"M36":3 %p61};
//   %p62 = (128, 0);
//   %wire_103 = &"net6" @WIRE(mode="straight") {#"I5":6 %p62};
//   %wire_104 = &"net6" @WIRE(mode="straight") {%p62 #"M47":3};
//   %wire_105 = &"net6" @WIRE(mode="straight") {#"C4":1 %p62};
//   %p63 = (56, 88);
//   %wire_106 = &"PHI1EP" @WIRE(mode="straight") {%p63 #"M58":2};
//   %wire_106 @TEXT("PHI1EP", size=1, halign="middle", valign="baseline") => @PLACE(57, 88.7);
//   %p64 = (135, -12);
//   %wire_107 = &"PHI2N" @WIRE(mode="straight") {#"I5":3 %p64};
//   %p65 = (23, -12);
//   %wire_108 = &"PHI2N" @WIRE(mode="straight") {#"I7":3 %p65};
//   %p66 = (-7, -12);
//   %wire_109 = &"PHI2N" @WIRE(mode="straight") {%p66 #"I3":3};
//   %p67 = (105, -12);
//   %wire_110 = &"PHI2N" @WIRE(mode="straight") {%p67 #"I8":3};
//   %wire_107 @TEXT("PHI2N", size=1, halign="middle", valign="baseline") => @PLACE(134, -11.3);
//   %wire_109 @TEXT("PHI2N", size=1, halign="middle", valign="baseline") => @PLACE(-6, -11.3);
//   %wire_110 @TEXT("PHI2N", size=1, halign="middle", valign="baseline") => @PLACE(106, -11.3);
//   %wire_108 @TEXT("PHI2N", size=1, halign="middle", valign="baseline") => @PLACE(22, -11.3);
//   %p68 = (76, 9);
//   %wire_111 = &"net4" @WIRE(mode="straight") {%p68 #"M68":3};
//   %p69 = (77, 8);
//   %wire_112 = &"net4" @WIRE(mode="straight") {#"M62":3 %p69};
//   %p70 = (88, 8);
//   %wire_113 = &"net4" @WIRE(mode="straight") {#"M33":1 %p70};
//   %p71 = (77, 9);
//   %wire_114 = &"net4" @WIRE(mode="straight") {%p69 %p71};
//   %wire_115 = &"net4" @WIRE(mode="straight") {#"M78":1 %p68};
//   %wire_116 = &"net4" @WIRE(mode="straight") {%p68 %p71};
//   %wire_117 = &"net4" @WIRE(mode="straight") {%p69 %p70};
//   %wire_118 = &"net4" @WIRE(mode="straight") {%p70 #"M57":3};
//   %wire_119 = &"PHI1BSTN" @WIRE(mode="straight") {#"M47":2 %port_11:p};
//   %p72 = (52, 48);
//   %p73 = (64, 48);
//   %wire_120 = &"net8" @WIRE(mode="straight") {%p72 %p73};
//   %p74 = (76, 48);
//   %wire_121 = &"net8" @WIRE(mode="straight") {%p74 #"M8":3};
//   %wire_122 = &"net8" @WIRE(mode="straight") {%p73 %p74};
//   %wire_123 = &"net8" @WIRE(mode="straight") {#"M41":1 %p73};
//   %wire_124 = &"net8" @WIRE(mode="straight") {%p72 #"M9":3};
//   %p75 = (56, -24);
//   %wire_125 = &"VB" @WIRE(mode="straight") {#"M1":2 %p75};
//   %wire_126 = &"VB" @WIRE(mode="straight") {%port_17:p %p75};
//   %wire_127 = &"VB" @WIRE(mode="straight") {%p75 #"M0":2};
//   %wire_128 = &"VOSN" @WIRE(mode="straight") {%port_18:p #"M33":2};
//   %p76 = (16, 0);
//   %wire_129 = &"VINP0" @WIRE(mode="straight") {#"C3":2 %p76};
//   %wire_130 = &"VINP0" @WIRE(mode="straight") {%p76 #"M77":2};
//   %wire_131 = &"VINP0" @WIRE(mode="straight") {#"I7":6 %p76};
//   %wire_130 @TEXT("VINP0", size=1, halign="middle", valign="baseline") => @PLACE(32, 0.7);
//   %p77 = (169, 49);
//   %wire_132 = &"DP" @WIRE(mode="straight") {%p77 #"I13":2};
//   %p78 = (120, 64);
//   %wire_133 = &"DP" @WIRE(mode="straight") {%p78 #"M38":1};
//   %wire_134 = &"DP" @WIRE(mode="straight") {#"M43":1 %p78};
//   %p79 = (136, 64);
//   %wire_135 = &"DP" @WIRE(mode="straight") {%p79 %p78};
//   %wire_136 = &"DP" @WIRE(mode="straight") {%p79 #"M37":1};
//   %p80 = (144, 64);
//   %wire_137 = &"DP" @WIRE(mode="straight") {%p80 %port_1:p %p79};
//   %wire_132 @TEXT("DP", size=1, halign="middle", valign="baseline") => @PLACE(171, 49.7);
//   %p81 = (112, 64);
//   %p82 = (112, 72);
//   %wire_138 = &"net7" @WIRE(mode="straight") {%p81 %p82};
//   %wire_139 = &"net7" @WIRE(mode="straight") {#"M38":2 %p82};
//   %p83 = (112, 56);
//   %wire_140 = &"net7" @WIRE(mode="straight") {%p83 #"M43":2};
//   %wire_141 = &"net7" @WIRE(mode="straight") {%p83 %p81};
//   %p84 = (104, 64);
//   %wire_142 = &"net7" @WIRE(mode="straight") {#"M10":1 %p84};
//   %wire_143 = &"net7" @WIRE(mode="straight") {%p84 %p81};
//   %wire_144 = &"net7" @WIRE(mode="straight") {%p84 #"M21":1};
//   %p85 = (16, -15);
//   %wire_145 = &"VCM" @WIRE(mode="straight") {#"I7":1 %p85};
//   %p86 = (16, -24);
//   %wire_146 = &"VCM" @WIRE(mode="straight") {%p86 #"I7":1};
//   %p87 = (112, -24);
//   %wire_147 = &"VCM" @WIRE(mode="straight") {%p87 #"I8":1};
//   %p88 = (80, 40);
//   %wire_148 = &"PHI1EPBST" @WIRE(mode="straight") {#"M57":2 %p88};
//   %p89 = (32, 40);
//   %wire_149 = &"PHI1EPBST" @WIRE(mode="straight") {#"M56":2 %p89};
//   %wire_148 @TEXT("PHI1EPBST", size=1, halign="middle", valign="baseline") => @PLACE(81, 40.7);
//   %wire_149 @TEXT("PHI1EPBST", size=1, halign="middle", valign="baseline") => @PLACE(34, 40.7);
//   %wire_150 = &"net10" @WIRE(mode="straight") {#"M44":1 #"M43":3};
//   %wire_151 = &"net10" @WIRE(mode="straight") {#"M55":1 #"M42":3};
//   %wire_152 = &"net10" @WIRE(mode="straight") {#"M55":1 #"M44":1};
//   %p90 = (112, 0);
//   %wire_153 = &"VINN0" @WIRE(mode="straight") {%p90 #"C4":2};
//   %wire_154 = &"VINN0" @WIRE(mode="straight") {#"I8":6 %p90};
//   %wire_155 = &"VINN0" @WIRE(mode="straight") {#"M78":2 %p90};
//   %wire_155 @TEXT("VINN0", size=1, halign="middle", valign="baseline") => @PLACE(96, 0.7);
//   %p91 = (176, 24);
//   %wire_156 = &"VSS" @WIRE(mode="straight") {%p91 #"I16":4};
//   %p92 = (176, 56);
//   %wire_157 = &"VSS" @WIRE(mode="straight") {#"I13":4 %p92};
//   %p93 = (72, 17);
//   %wire_158 = &"VSS" @WIRE(mode="straight") {%p93 #"M68":4};
//   %p94 = (124, 55);
//   %wire_159 = &"VSS" @WIRE(mode="straight") {#"M43":4 %p94};
//   %p95 = (119, 45);
//   %p96 = (119, 47);
//   %wire_160 = &"VSS" @WIRE(mode="straight") {%p95 %p96};
//   %wire_161 = &"VSS" @WIRE(mode="straight") {%p95 #"M44":3};
//   %p97 = (53, -41);
//   %wire_162 = &"VSS" @WIRE(mode="straight") {%p97 #"M1":3};
//   %p98 = (44, 39);
//   %wire_163 = &"VSS" @WIRE(mode="straight") {%p98 #"M56":4};
//   %p99 = (65, 37);
//   %wire_164 = &"VSS" @WIRE(mode="straight") {#"M41":3 %p99};
//   %p100 = (55, -41);
//   %wire_165 = &"VSS" @WIRE(mode="straight") {%p97 %p100};
//   %p101 = (59, -41);
//   %wire_166 = &"VSS" @WIRE(mode="straight") {%p101 #"M1":1};
//   %p102 = (120, 40);
//   %wire_167 = &"VSS" @WIRE(mode="straight") {%p102 #"M44":3};
//   %wire_168 = &"VSS" @WIRE(mode="straight") {%p100 #"M1":4};
//   %p103 = (64, 32);
//   %wire_169 = &"VSS" @WIRE(mode="straight") {%p103 #"M41":3};
//   %p104 = (56, 17);
//   %wire_170 = &"VSS" @WIRE(mode="straight") {%p104 #"M63":4};
//   %wire_171 = &"VSS" @WIRE(mode="straight") {#"I3":4 #"I7":4};
//   %p105 = (65, 39);
//   %wire_172 = &"VSS" @WIRE(mode="straight") {#"M41":4 %p105};
//   %p106 = (9, 45);
//   %wire_173 = &"VSS" @WIRE(mode="straight") {#"M55":3 %p106};
//   %p107 = (44, -9);
//   %wire_174 = &"VSS" @WIRE(mode="straight") {#"M32":4 %p107};
//   %p108 = (4, 55);
//   %wire_175 = &"VSS" @WIRE(mode="straight") {%p108 #"M42":4};
//   %wire_176 = &"VSS" @WIRE(mode="straight") {%p100 %p101};
//   %p109 = (8, 40);
//   %wire_177 = &"VSS" @WIRE(mode="straight") {%p109 #"M55":3};
//   %p110 = (9, 47);
//   %wire_178 = &"VSS" @WIRE(mode="straight") {%p106 %p110};
//   %wire_179 = &"VSS" @WIRE(mode="straight") {#"M55":4 %p110};
//   %wire_180 = &"VSS" @WIRE(mode="straight") {%p99 %p105};
//   %p111 = (20, 55);
//   %wire_181 = &"VSS" @WIRE(mode="straight") {%p111 #"M23":4};
//   %wire_182 = &"VSS" @WIRE(mode="straight") {%p96 #"M44":4};
//   %p112 = (108, 55);
//   %wire_183 = &"VSS" @WIRE(mode="straight") {#"M10":4 %p112};
//   %p113 = (104, 48);
//   %wire_184 = &"VSS" @WIRE(mode="straight") {%p113 #"M10":3};
//   %p114 = (84, -9);
//   %wire_185 = &"VSS" @WIRE(mode="straight") {#"M33":4 %p114};
//   %p115 = (80, 55);
//   %wire_186 = &"VSS" @WIRE(mode="straight") {#"M8":4 %p115};
//   %p116 = (72, -1);
//   %wire_187 = &"VSS" @WIRE(mode="straight") {%p116 #"M78":4};
//   %p117 = (92, 39);
//   %wire_188 = &"VSS" @WIRE(mode="straight") {%p117 #"M57":4};
//   %p118 = (65, -27);
//   %p119 = (65, -25);
//   %wire_189 = &"VSS" @WIRE(mode="straight") {%p118 %p119};
//   %wire_190 = &"VSS" @WIRE(mode="straight") {#"M0":3 %p118};
//   %wire_191 = &"VSS" @WIRE(mode="straight") {#"M0":4 %p119};
//   %p120 = (56, -1);
//   %wire_192 = &"VSS" @WIRE(mode="straight") {#"M77":4 %p120};
//   %p121 = (64, -32);
//   %wire_193 = &"VSS" @WIRE(mode="straight") {%p121 #"M0":3};
//   %p122 = (-15, -4);
//   %wire_194 = &"VSS" @WIRE(mode="straight") {%p122 #"M36":4};
//   %p123 = (48, 55);
//   %wire_195 = &"VSS" @WIRE(mode="straight") {%p123 #"M9":4};
//   %p124 = (24, 48);
//   %wire_196 = &"VSS" @WIRE(mode="straight") {%p124 #"M23":3};
//   %p125 = (65, 4);
//   %wire_197 = &"VSS" @WIRE(mode="straight") {%p125 #"M62":4};
//   %p126 = (143, -4);
//   %wire_198 = &"VSS" @WIRE(mode="straight") {%p126 #"M47":4};
//   %wire_199 = &"VSS" @WIRE(mode="straight") {#"I8":4 #"I5":4};
//   %wire_184 @TEXT("VSS", size=1, halign="middle", valign="baseline", rotate=90) => @PLACE(103.3, 49);
//   %wire_170 @TEXT("VSS", size=1, halign="middle", valign="baseline") => @PLACE(54, 17.7);
//   %wire_198 @TEXT("VSS", size=1, halign="middle", valign="top", rotate=90) => @PLACE(143.7, -2);
//   %wire_171 @TEXT("VSS", size=1, halign="middle", valign="baseline") => @PLACE(8, -13.3);
//   %wire_192 @TEXT("VSS", size=1, halign="middle", valign="baseline") => @PLACE(55, -0.3);
//   %wire_193 @TEXT("VSS", size=1, halign="middle", valign="baseline", rotate=90) => @PLACE(63.3, -30);
//   %wire_187 @TEXT("VSS", size=1, halign="middle", valign="baseline") => @PLACE(74, -0.3);
//   %wire_158 @TEXT("VSS", size=1, halign="middle", valign="baseline") => @PLACE(74, 17.7);
//   %wire_188 @TEXT("VSS", size=1, halign="middle", valign="baseline") => @PLACE(90, 39.7);
//   %wire_195 @TEXT("VSS", size=1, halign="middle", valign="baseline") => @PLACE(49, 55.7);
//   %wire_186 @TEXT("VSS", size=1, halign="middle", valign="baseline") => @PLACE(79, 55.7);
//   %wire_181 @TEXT("VSS", size=1, halign="middle", valign="baseline") => @PLACE(22, 55.7);
//   %wire_183 @TEXT("VSS", size=1, halign="middle", valign="baseline") => @PLACE(106, 55.7);
//   %wire_196 @TEXT("VSS", size=1, halign="middle", valign="baseline", rotate=90) => @PLACE(23.3, 49);
//   %wire_159 @TEXT("VSS", size=1, halign="middle", valign="baseline") => @PLACE(123, 55.7);
//   %wire_185 @TEXT("VSS", size=1, halign="middle", valign="baseline") => @PLACE(85, -8.3);
//   %wire_174 @TEXT("VSS", size=1, halign="middle", valign="baseline") => @PLACE(43, -8.3);
//   %wire_194 @TEXT("VSS", size=1, halign="middle", valign="baseline", rotate=90) => @PLACE(-15.7, -2);
//   %wire_177 @TEXT("VSS", size=1, halign="middle", valign="baseline", rotate=90) => @PLACE(7.3, 41);
//   %wire_175 @TEXT("VSS", size=1, halign="middle", valign="baseline") => @PLACE(6, 55.7);
//   %wire_169 @TEXT("VSS", size=1, halign="middle", valign="baseline", rotate=90) => @PLACE(63.3, 34);
//   %wire_197 @TEXT("VSS", size=1, halign="middle", valign="baseline", rotate=90) => @PLACE(64.3, 6);
//   %wire_167 @TEXT("VSS", size=1, halign="middle", valign="top", rotate=90) => @PLACE(120.7, 41);
//   %wire_199 @TEXT("VSS", size=1, halign="middle", valign="baseline") => @PLACE(120, -13.3);
//   %wire_157 @TEXT("VSS", size=1, halign="middle", valign="baseline", rotate=90) => @PLACE(175.3, 55);
//   %wire_163 @TEXT("VSS", size=1, halign="middle", valign="baseline") => @PLACE(42, 39.7);
//   %wire_176 @TEXT("VSS", size=1, halign="middle", valign="baseline") => @PLACE(57, -40.3);
//   %wire_156 @TEXT("VSS", size=1, halign="middle", valign="baseline", rotate=90) => @PLACE(175.3, 26);
//   %wire_200 = &"VDD" @WIRE(mode="straight") {#"I16":3 #"I13":3};
//   %p127 = (65, 91);
//   %wire_201 = &"VDD" @WIRE(mode="straight") {#"M58":3 %p127};
//   %p128 = (64, 96);
//   %wire_202 = &"VDD" @WIRE(mode="straight") {#"M58":3 %p128};
//   %p129 = (80, 21);
//   %wire_203 = &"VDD" @WIRE(mode="straight") {#"M68":2 %p129};
//   %p130 = (48, 21);
//   %wire_204 = &"VDD" @WIRE(mode="straight") {#"M63":2 %p130};
//   %p131 = (135, -14);
//   %wire_205 = &"VDD" @WIRE(mode="straight") {#"I5":5 %p131};
//   %p132 = (120, 80);
//   %wire_206 = &"VDD" @WIRE(mode="straight") {#"M38":3 %p132};
//   %p133 = (124, 73);
//   %wire_207 = &"VDD" @WIRE(mode="straight") {#"M38":4 %p133};
//   %p134 = (136, 80);
//   %wire_208 = &"VDD" @WIRE(mode="straight") {#"M37":3 %p134};
//   %p135 = (140, 73);
//   %wire_209 = &"VDD" @WIRE(mode="straight") {#"M37":4 %p135};
//   %p136 = (76, 26);
//   %wire_210 = &"VDD" @WIRE(mode="straight") {#"M68":1 %p136};
//   %wire_211 = &"VDD" @WIRE(mode="straight") {%p129 #"M68":1};
//   %p137 = (52, 26);
//   %wire_212 = &"VDD" @WIRE(mode="straight") {#"M63":1 %p137};
//   %p138 = (-8, 80);
//   %wire_213 = &"VDD" @WIRE(mode="straight") {#"M31":3 %p138};
//   %p139 = (-12, 73);
//   %wire_214 = &"VDD" @WIRE(mode="straight") {#"M31":4 %p139};
//   %p140 = (-7, -14);
//   %wire_215 = &"VDD" @WIRE(mode="straight") {%p140 #"I3":5};
//   %p141 = (23, -14);
//   %wire_216 = &"VDD" @WIRE(mode="straight") {#"I7":5 %p141};
//   %p142 = (80, 73);
//   %wire_217 = &"VDD" @WIRE(mode="straight") {#"M87":4 %p142};
//   %wire_218 = &"VDD" @WIRE(mode="straight") {%p130 #"M63":1};
//   %p143 = (8, 80);
//   %wire_219 = &"VDD" @WIRE(mode="straight") {#"M30":3 %p143};
//   %p144 = (48, 73);
//   %wire_220 = &"VDD" @WIRE(mode="straight") {%p144 #"M12":4};
//   %p145 = (64, 18);
//   %wire_221 = &"VDD" @WIRE(mode="straight") {#"M62":2 %p145};
//   %p146 = (105, -14);
//   %wire_222 = &"VDD" @WIRE(mode="straight") {%p146 #"I8":5};
//   %p147 = (65, 89);
//   %wire_223 = &"VDD" @WIRE(mode="straight") {%p147 %p127};
//   %p148 = (20, 73);
//   %wire_224 = &"VDD" @WIRE(mode="straight") {#"M22":4 %p148};
//   %wire_225 = &"VDD" @WIRE(mode="straight") {#"M58":4 %p147};
//   %p149 = (108, 73);
//   %wire_226 = &"VDD" @WIRE(mode="straight") {#"M21":4 %p149};
//   %p150 = (4, 73);
//   %wire_227 = &"VDD" @WIRE(mode="straight") {#"M30":4 %p150};
//   %wire_227 @TEXT("VDD", size=1, halign="middle", valign="baseline") => @PLACE(5, 73.7);
//   %wire_205 @TEXT("VDD", size=1, halign="middle", valign="baseline") => @PLACE(134, -13.3);
//   %wire_224 @TEXT("VDD", size=1, halign="middle", valign="baseline") => @PLACE(21, 73.7);
//   %wire_220 @TEXT("VDD", size=1, halign="middle", valign="baseline") => @PLACE(50, 73.7);
//   %wire_217 @TEXT("VDD", size=1, halign="middle", valign="baseline") => @PLACE(79, 73.7);
//   %wire_210 @TEXT("VDD", size=1, halign="middle", valign="top", rotate=90) => @PLACE(76.7, 24);
//   %wire_226 @TEXT("VDD", size=1, halign="middle", valign="baseline") => @PLACE(107, 73.7);
//   %wire_219 @TEXT("VDD", size=1, halign="middle", valign="top", rotate=90) => @PLACE(8.7, 78);
//   %wire_202 @TEXT("VDD", size=1, halign="middle", valign="baseline", rotate=90) => @PLACE(63.3, 94);
//   %wire_214 @TEXT("VDD", size=1, halign="middle", valign="baseline") => @PLACE(-11, 73.7);
//   %wire_213 @TEXT("VDD", size=1, halign="middle", valign="top", rotate=90) => @PLACE(-7.3, 78);
//   %wire_222 @TEXT("VDD", size=1, halign="middle", valign="baseline") => @PLACE(106, -13.3);
//   %wire_209 @TEXT("VDD", size=1, halign="middle", valign="baseline") => @PLACE(139, 73.7);
//   %wire_208 @TEXT("VDD", size=1, halign="middle", valign="baseline", rotate=90) => @PLACE(135.3, 78);
//   %wire_215 @TEXT("VDD", size=1, halign="middle", valign="baseline") => @PLACE(-6, -13.3);
//   %wire_207 @TEXT("VDD", size=1, halign="middle", valign="baseline") => @PLACE(123, 73.7);
//   %wire_206 @TEXT("VDD", size=1, halign="middle", valign="baseline", rotate=90) => @PLACE(119.3, 78);
//   %wire_212 @TEXT("VDD", size=1, halign="middle", valign="baseline", rotate=90) => @PLACE(51.3, 24);
//   %wire_221 @TEXT("VDD", size=1, halign="middle", valign="baseline", rotate=90) => @PLACE(63.3, 17);
//   %wire_216 @TEXT("VDD", size=1, halign="middle", valign="baseline") => @PLACE(22, -13.3);
//   %wire_200 @TEXT("VDD", size=1, halign="middle", valign="baseline", rotate=90) => @PLACE(175.3, 40);
//   %wire_228 = &"VINP" @WIRE(mode="straight") {%port_4:p #"M36":1};
//   $JUNCTION @ATTACH %p0;
//   $JUNCTION @ATTACH %p1;
//   $JUNCTION @ATTACH %p2;
//   $JUNCTION @ATTACH %p8;
//   $JUNCTION @ATTACH %p10;
//   $JUNCTION @ATTACH %p12;
//   $JUNCTION @ATTACH %p13;
//   $JUNCTION @ATTACH %p15;
//   $JUNCTION @ATTACH %p16;
//   $JUNCTION @ATTACH %p19;
//   $JUNCTION @ATTACH %p23;
//   $JUNCTION @ATTACH %p24;
//   $JUNCTION @ATTACH %p28;
//   $JUNCTION @ATTACH %p32;
//   $JUNCTION @ATTACH %p33;
//   $JUNCTION @ATTACH %p35;
//   $JUNCTION @ATTACH %p38;
//   $JUNCTION @ATTACH %p39;
//   $JUNCTION @ATTACH %p42;
//   $JUNCTION @ATTACH %p43;
//   $JUNCTION @ATTACH %p49;
//   $JUNCTION @ATTACH %p50;
//   $JUNCTION @ATTACH %p51;
//   $JUNCTION @ATTACH %p53;
//   $JUNCTION @ATTACH %p54;
//   $JUNCTION @ATTACH %p57;
//   $JUNCTION @ATTACH %p61;
//   $JUNCTION @ATTACH %p62;
//   $JUNCTION @ATTACH %p68;
//   $JUNCTION @ATTACH %p69;
//   $JUNCTION @ATTACH %p70;
//   $JUNCTION @ATTACH %p73;
//   $JUNCTION @ATTACH %p75;
//   $JUNCTION @ATTACH %p76;
//   $JUNCTION @ATTACH %p78;
//   $JUNCTION @ATTACH %p79;
//   $JUNCTION @ATTACH %p81;
//   $JUNCTION @ATTACH %p84;
//   $JUNCTION @ATTACH %p90;
//   $JUNCTION @ATTACH %p100
// }
ends L4_stage1_flash_comparator
