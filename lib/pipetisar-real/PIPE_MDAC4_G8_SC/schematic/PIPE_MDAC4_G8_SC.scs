// RNL cell 2026_PIPETISAR_RESEARCH/PIPE_MDAC4_G8_SC
// @RNL(type="header") {
//   @VERSION("0.3");
//   @USE-PACKAGE(name="rnl-std-spectre", version="0.3", path="rnl-std-spectre.rnl");
//   @USE-PACKAGE(name="eda-symbol", version="0.1", path="eda-symbol.rnl");
//   @USE-PACKAGE(name="eda-style", version="0.1", path="eda-style.rnl")
// }
subckt PIPE_MDAC4_G8_SC AMP DACN DACP RESET RON ROP TRACK VCM VDD VINN \
        VINP VSS
    XOTA (VCM VDD XP XN ROP RON) PIPE_OTA_Diff_Ideal gm=GmIdeal gm_id=20 \
        Gain=AolIdeal
    CFN (XP RON) capacitor c=Cs1/8
    CSN (BN XP) capacitor c=Cs1
    CFP (XN ROP) capacitor c=Cs1/8
    CSP (BP XN) capacitor c=Cs1
    XLIMIT (ROP RON VDD VSS) PIPE_RailClamp gclamp=100 margin=20m knee=1m \
        enable=LimitEnable
    S_RESETN (XP RON RESET) Switch Rseries=100m
    S_DACN (DACN BN AMP) Switch Rseries=5
    S_INN (VINN BN TRACK) Switch Rseries=100m
    S_RESETP (XN ROP RESET) Switch Rseries=100m
    S_DACP (DACP BP AMP) Switch Rseries=5
    S_INP (VINP BP TRACK) Switch Rseries=100m
// @RNL(author="rnl-virtuoso") {
//   %block_symbol = @DEFINE-SYMBOL(box=[0, -92.8, 70.4, 4.8]) {
//     @RECTANGLE {(0, -92.8) (70.4, 4.8)};
//     (35.2, 10.4) @TEXT("SC MDAC  /  G = 8", size=4.6, halign="middle", valign="middle");
//     ? @TEXT("${name}", size=3.8, halign="middle", valign="middle", key="name") => @PLACE(35.2, -97.9);
//     (0, 0) @PIN(terminal="VINP");
//     (2.2, 0) @TEXT("VINP", size=3.8, halign="start", valign="middle");
//     (0, -12.8) @PIN(terminal="VINN");
//     (2.2, -12.8) @TEXT("VINN", size=3.8, halign="start", valign="middle");
//     (0, -48) @PIN(terminal="DACP");
//     (2.2, -48) @TEXT("DACP", size=3.8, halign="start", valign="middle");
//     (0, -60.8) @PIN(terminal="DACN");
//     (2.2, -60.8) @TEXT("DACN", size=3.8, halign="start", valign="middle");
//     (0, -72) @PIN(terminal="TRACK");
//     (2.2, -72) @TEXT("TRACK", size=3.8, halign="start", valign="middle");
//     (0, -80) @PIN(terminal="AMP");
//     (2.2, -80) @TEXT("AMP", size=3.8, halign="start", valign="middle");
//     (0, -88) @PIN(terminal="RESET");
//     (2.2, -88) @TEXT("RESET", size=3.8, halign="start", valign="middle");
//     (70.4, 0) @PIN(terminal="ROP");
//     (68.2, 0) @TEXT("ROP", size=3.8, halign="end", valign="middle");
//     (70.4, -12.8) @PIN(terminal="RON");
//     (68.2, -12.8) @TEXT("RON", size=3.8, halign="end", valign="middle");
//     (70.4, -60.8) @PIN(terminal="VCM");
//     (68.2, -60.8) @TEXT("VCM", size=3.8, halign="end", valign="middle");
//     (70.4, -68.8) @PIN(terminal="VDD");
//     (68.2, -68.8) @TEXT("VDD", size=3.8, halign="end", valign="middle");
//     (70.4, -76.8) @PIN(terminal="VSS");
//     (68.2, -76.8) @TEXT("VSS", size=3.8, halign="end", valign="middle")
//   };
//   # @SET-SYMBOL %block_symbol;
//   #"S_INP" @PLACE(12, 24) => @ORIENT("R0");
//   #"CSP" @SET-SYMBOL $CAPACITOR;
//   #"CSP" @PLACE(51, 24) => @ORIENT("R90");
//   #"S_DACP" @PLACE(12, 0) => @ORIENT("R0");
//   #"S_INN" @PLACE(12, -48) => @ORIENT("R0");
//   #"CFN" @SET-SYMBOL $CAPACITOR;
//   #"CFN" @PLACE(99, -80) => @ORIENT("R90");
//   #"CFP" @SET-SYMBOL $CAPACITOR;
//   #"CFP" @PLACE(99, 56) => @ORIENT("R90");
//   #"S_RESETP" @PLACE(92, 80) => @ORIENT("R0");
//   #"S_RESETN" @PLACE(92, -104) => @ORIENT("R0");
//   #"S_DACN" @PLACE(12, -72) => @ORIENT("R0");
//   #"CSN" @SET-SYMBOL $CAPACITOR;
//   #"CSN" @PLACE(51, -48) => @ORIENT("R90");
//   %symbol_0 = @DEFINE-SYMBOL(box=[0, -16, 38.4, 3.2]) {
//     @RECTANGLE {(0, -16) (38.4, 3.2)};
//     (19.2, -12) @TEXT("RAIL CLAMP", size=2.9, halign="middle", valign="middle");
//     ? @TEXT("${name}", size=2.4, halign="middle", valign="middle", key="name") => @PLACE(19.2, 7.2);
//     (0, 0) @PIN(terminal=1);
//     (1.6, 0) @TEXT("P", size=2.6, halign="start", valign="middle");
//     (0, -5.6) @PIN(terminal=2);
//     (1.6, -5.6) @TEXT("N", size=2.6, halign="start", valign="middle");
//     (38.4, 0) @PIN(terminal=3);
//     (36.8, 0) @TEXT("VDD", size=2.6, halign="end", valign="middle");
//     (38.4, -5.6) @PIN(terminal=4);
//     (36.8, -5.6) @TEXT("VSS", size=2.6, halign="end", valign="middle")
//   };
//   #"XLIMIT" @SET-SYMBOL %symbol_0;
//   #"XLIMIT" @PLACE(168, 32) => @ORIENT("R0");
//   #"XOTA" @PLACE(96, -8) => @ORIENT("MX");
//   %output_port_symbol = @DEFINE-SYMBOL(box=[0, -1, 2, 1]) {
//       @LINE(fill="linecolor", linestyle="none") {(0, -0.9) (0, 0.9) (1.1, 0.9) (2, 0) (1.1, -0.9) (0, -0.9)};
//       (0, 0) @PIN(terminal=1, direction="left");
//       ? @TEXT("${name}", key="name", halign="middle") => @PLACE(1, 1.6)
//     };
//   %port_0 = $IO_PORT @ATTACH &"RON" => @PLACE(176, -148.8) => @ORIENT("R0");
//   %port_0 @SET-SYMBOL %output_port_symbol;
//   %port_0 @TEXT("RON", key="name");
//   %port_1 = $IO_PORT @ATTACH &"ROP" => @PLACE(140.8, -148.8) => @ORIENT("R0");
//   %port_1 @SET-SYMBOL %output_port_symbol;
//   %port_1 @TEXT("ROP", key="name");
//   %input_port_symbol = @DEFINE-SYMBOL(box=[-2, -1, 0, 1]) {
//       @LINE(fill="linecolor", linestyle="none") {(-2, -0.9) (-2, 0.9) (-0.9, 0.9) (0, 0) (-0.9, -0.9) (-2, -0.9)};
//       (0, 0) @PIN(terminal=1, direction="right");
//       ? @TEXT("${name}", key="name", halign="middle") => @PLACE(-1, 1.6)
//     };
//   %port_2 = $IO_PORT @ATTACH &"VCM" => @PLACE(105.6, -148.8) => @ORIENT("R0");
//   %port_2 @SET-SYMBOL %input_port_symbol;
//   %port_2 @TEXT("VCM", key="name");
//   %port_3 = $IO_PORT @ATTACH &"VSS" => @PLACE(70.4, -148.8) => @ORIENT("R0");
//   %port_3 @SET-SYMBOL %input_port_symbol;
//   %port_3 @TEXT("VSS", key="name");
//   %port_4 = $IO_PORT @ATTACH &"VDD" => @PLACE(35.2, -148.8) => @ORIENT("R0");
//   %port_4 @SET-SYMBOL %input_port_symbol;
//   %port_4 @TEXT("VDD", key="name");
//   %port_5 = $IO_PORT @ATTACH &"RESET" => @PLACE(0, -148.8) => @ORIENT("R0");
//   %port_5 @SET-SYMBOL %input_port_symbol;
//   %port_5 @TEXT("RESET", key="name");
//   %port_6 = $IO_PORT @ATTACH &"AMP" => @PLACE(176, -139.2) => @ORIENT("R0");
//   %port_6 @SET-SYMBOL %input_port_symbol;
//   %port_6 @TEXT("AMP", key="name");
//   %port_7 = $IO_PORT @ATTACH &"TRACK" => @PLACE(140.8, -139.2) => @ORIENT("R0");
//   %port_7 @SET-SYMBOL %input_port_symbol;
//   %port_7 @TEXT("TRACK", key="name");
//   %port_8 = $IO_PORT @ATTACH &"DACN" => @PLACE(105.6, -139.2) => @ORIENT("R0");
//   %port_8 @SET-SYMBOL %input_port_symbol;
//   %port_8 @TEXT("DACN", key="name");
//   %port_9 = $IO_PORT @ATTACH &"DACP" => @PLACE(70.4, -139.2) => @ORIENT("R0");
//   %port_9 @SET-SYMBOL %input_port_symbol;
//   %port_9 @TEXT("DACP", key="name");
//   %port_10 = $IO_PORT @ATTACH &"VINN" => @PLACE(35.2, -139.2) => @ORIENT("R0");
//   %port_10 @SET-SYMBOL %input_port_symbol;
//   %port_10 @TEXT("VINN", key="name");
//   %port_11 = $IO_PORT @ATTACH &"VINP" => @PLACE(0, -139.2) => @ORIENT("R0");
//   %port_11 @SET-SYMBOL %input_port_symbol;
//   %port_11 @TEXT("VINP", key="name");
//   %p0 = (92.8, -104);
//   %wire_0 = &"XP" @WIRE(mode="straight") {#"S_RESETN":1 %p0};
//   %p1 = (92.8, -80);
//   %wire_1 = &"XP" @WIRE(mode="straight") {%p1 #"CFN":1};
//   %p2 = (92.8, -48);
//   %wire_2 = &"XP" @WIRE(mode="straight") {%p1 %p2};
//   %wire_3 = &"XP" @WIRE(mode="straight") {#"CSN":2 %p2};
//   %wire_4 = &"XP" @WIRE(mode="straight") {%p0 %p1};
//   %p3 = (92.8, -11);
//   %wire_5 = &"XP" @WIRE(mode="straight") {%p2 %p3};
//   %wire_6 = &"XP" @WIRE(mode="straight") {%p3 #"XOTA":3};
//   %wire_3 @TEXT("XP", size=2.4, halign="middle", valign="baseline") => @PLACE(73.4, -48);
//   %wire_1 @TEXT("XP", size=2.4, halign="middle", valign="baseline") => @PLACE(94.4, -80);
//   %p4 = (88, 56);
//   %wire_7 = &"XN" @WIRE(mode="straight") {%p4 #"CFP":1};
//   %p5 = (88, 24);
//   %wire_8 = &"XN" @WIRE(mode="straight") {%p5 %p4};
//   %wire_9 = &"XN" @WIRE(mode="straight") {#"CSP":2 %p5};
//   %p6 = (88, 80);
//   %wire_10 = &"XN" @WIRE(mode="straight") {%p4 %p6};
//   %p7 = (88, -7);
//   %wire_11 = &"XN" @WIRE(mode="straight") {%p7 %p5};
//   %wire_12 = &"XN" @WIRE(mode="straight") {%p7 #"XOTA":4};
//   %wire_13 = &"XN" @WIRE(mode="straight") {%p6 #"S_RESETP":1};
//   %wire_9 @TEXT("XN", size=2.4, halign="middle", valign="baseline") => @PLACE(71, 24);
//   %wire_13 @TEXT("XN", size=2.4, halign="middle", valign="baseline") => @PLACE(88.8, 80);
//   %wire_7 @TEXT("XN", size=2.4, halign="middle", valign="baseline") => @PLACE(92, 56);
//   %p8 = (32, 24);
//   %wire_14 = &"BP" @WIRE(mode="straight") {#"S_INP":2 %p8};
//   %p9 = (32, 0);
//   %wire_15 = &"BP" @WIRE(mode="straight") {#"S_DACP":2 %p9};
//   %wire_16 = &"BP" @WIRE(mode="straight") {%p8 #"CSP":1};
//   %wire_17 = &"BP" @WIRE(mode="straight") {%p9 %p8};
//   %wire_15 @TEXT("BP", size=2.4, halign="middle", valign="baseline") => @PLACE(27.2, 0);
//   %wire_16 @TEXT("BP", size=2.4, halign="middle", valign="baseline") => @PLACE(35.2, 24);
//   %p10 = (32, -48);
//   %wire_18 = &"BN" @WIRE(mode="straight") {#"S_INN":2 %p10};
//   %p11 = (32, -72);
//   %wire_19 = &"BN" @WIRE(mode="straight") {#"S_DACN":2 %p11};
//   %wire_20 = &"BN" @WIRE(mode="straight") {%p10 #"CSN":1};
//   %wire_21 = &"BN" @WIRE(mode="straight") {%p11 %p10};
//   %wire_19 @TEXT("BN", size=2.4, halign="middle", valign="baseline") => @PLACE(27.2, -72);
//   %wire_20 @TEXT("BN", size=2.4, halign="middle", valign="baseline") => @PLACE(35.2, -48);
//   %p12 = (164, 26.4);
//   %wire_22 = &"RON" @WIRE(mode="straight") {%p12 #"XLIMIT":2};
//   %p13 = (150.4, -104);
//   %wire_23 = &"RON" @WIRE(mode="straight") {#"S_RESETN":2 %p13};
//   %p14 = (150.4, -80);
//   %wire_24 = &"RON" @WIRE(mode="straight") {%p13 %p14};
//   %wire_25 = &"RON" @WIRE(mode="straight") {#"CFN":2 %p14};
//   %p15 = (150.4, -11);
//   %wire_26 = &"RON" @WIRE(mode="straight") {%p14 %p15};
//   %wire_27 = &"RON" @WIRE(mode="straight") {#"XOTA":6 %p15};
//   %p16 = (180, -148.8);
//   %wire_28 = &"RON" @WIRE(mode="straight") {%port_0:p %p16};
//   %wire_28 @TEXT("RON", size=1.9, halign="middle", valign="baseline") => @PLACE(178, -148.8);
//   %wire_25 @TEXT("RON", size=2.4, halign="middle", valign="baseline") => @PLACE(126.2, -80);
//   %wire_23 @TEXT("RON", size=2.4, halign="middle", valign="baseline") => @PLACE(126.4, -104);
//   %wire_22 @TEXT("RON", size=2.2, halign="middle", valign="baseline") => @PLACE(166, 26.4);
//   %p17 = (164, 32);
//   %wire_29 = &"ROP" @WIRE(mode="straight") {%p17 #"XLIMIT":1};
//   %p18 = (144, 80);
//   %wire_30 = &"ROP" @WIRE(mode="straight") {#"S_RESETP":2 %p18};
//   %p19 = (144, 56);
//   %wire_31 = &"ROP" @WIRE(mode="straight") {%p19 %p18};
//   %wire_32 = &"ROP" @WIRE(mode="straight") {#"CFP":2 %p19};
//   %p20 = (144, -7);
//   %wire_33 = &"ROP" @WIRE(mode="straight") {%p20 %p19};
//   %wire_34 = &"ROP" @WIRE(mode="straight") {#"XOTA":5 %p20};
//   %p21 = (144.8, -148.8);
//   %wire_35 = &"ROP" @WIRE(mode="straight") {%port_1:p %p21};
//   %wire_35 @TEXT("ROP", size=1.9, halign="middle", valign="baseline") => @PLACE(142.8, -148.8);
//   %wire_32 @TEXT("ROP", size=2.4, halign="middle", valign="baseline") => @PLACE(123, 56);
//   %wire_30 @TEXT("ROP", size=2.4, halign="middle", valign="baseline") => @PLACE(123.2, 80);
//   %wire_29 @TEXT("ROP", size=2.2, halign="middle", valign="baseline") => @PLACE(166, 32);
//   %p22 = (129.5, -9);
//   %wire_36 = &"VCM" @WIRE(mode="straight") {#"XOTA":1 %p22};
//   %p23 = (109.6, -148.8);
//   %wire_37 = &"VCM" @WIRE(mode="straight") {%port_2:p %p23};
//   %wire_37 @TEXT("VCM", size=1.9, halign="middle", valign="baseline") => @PLACE(107.6, -148.8);
//   %wire_36 @TEXT("VCM", size=2.4, halign="start", valign="middle") => @PLACE(131.1, -9);
//   %p24 = (16, -38.1);
//   %wire_38 = &"TRACK" @WIRE(mode="straight") {#"S_INN":3 %p24};
//   %p25 = (16, 33.9);
//   %wire_39 = &"TRACK" @WIRE(mode="straight") {#"S_INP":3 %p25};
//   %p26 = (144.8, -139.2);
//   %wire_40 = &"TRACK" @WIRE(mode="straight") {%port_7:p %p26};
//   %wire_40 @TEXT("TRACK", size=1.9, halign="middle", valign="baseline") => @PLACE(142.8, -139.2);
//   %wire_39 @TEXT("TRACK", size=2.4, halign="start", valign="baseline") => @PLACE(16.6, 34.4);
//   %wire_38 @TEXT("TRACK", size=2.4, halign="start", valign="baseline") => @PLACE(16.6, -37.6);
//   %p27 = (210.4, 32);
//   %wire_41 = &"VDD" @WIRE(mode="straight") {#"XLIMIT":3 %p27};
//   %p28 = (116, -18.5);
//   %wire_42 = &"VDD" @WIRE(mode="straight") {%p28 #"XOTA":2};
//   %p29 = (39.2, -148.8);
//   %wire_43 = &"VDD" @WIRE(mode="straight") {%port_4:p %p29};
//   %wire_43 @TEXT("VDD", size=1.9, halign="middle", valign="baseline") => @PLACE(37.2, -148.8);
//   %wire_42 @TEXT("VDD", size=2.4, halign="start", valign="top") => @PLACE(116.6, -19);
//   %wire_41 @TEXT("VDD", size=2.2, halign="middle", valign="baseline") => @PLACE(208.4, 32);
//   %p30 = (16, -62.1);
//   %wire_44 = &"AMP" @WIRE(mode="straight") {#"S_DACN":3 %p30};
//   %p31 = (16, 9.9);
//   %wire_45 = &"AMP" @WIRE(mode="straight") {#"S_DACP":3 %p31};
//   %p32 = (180, -139.2);
//   %wire_46 = &"AMP" @WIRE(mode="straight") {%port_6:p %p32};
//   %wire_46 @TEXT("AMP", size=1.9, halign="middle", valign="baseline") => @PLACE(178, -139.2);
//   %wire_45 @TEXT("AMP", size=2.4, halign="start", valign="baseline") => @PLACE(16.6, 10.4);
//   %wire_44 @TEXT("AMP", size=2.4, halign="start", valign="baseline") => @PLACE(16.6, -61.6);
//   %p33 = (96, -94.1);
//   %wire_47 = &"RESET" @WIRE(mode="straight") {#"S_RESETN":3 %p33};
//   %p34 = (96, 89.9);
//   %wire_48 = &"RESET" @WIRE(mode="straight") {#"S_RESETP":3 %p34};
//   %p35 = (4, -148.8);
//   %wire_49 = &"RESET" @WIRE(mode="straight") {%port_5:p %p35};
//   %wire_49 @TEXT("RESET", size=1.9, halign="middle", valign="baseline") => @PLACE(2, -148.8);
//   %wire_48 @TEXT("RESET", size=2.4, halign="start", valign="baseline") => @PLACE(96.6, 90.4);
//   %wire_47 @TEXT("RESET", size=2.4, halign="start", valign="baseline") => @PLACE(96.6, -93.6);
//   %p36 = (210.4, 26.4);
//   %wire_50 = &"VSS" @WIRE(mode="straight") {#"XLIMIT":4 %p36};
//   %p37 = (74.4, -148.8);
//   %wire_51 = &"VSS" @WIRE(mode="straight") {%port_3:p %p37};
//   %wire_51 @TEXT("VSS", size=1.9, halign="middle", valign="baseline") => @PLACE(72.4, -148.8);
//   %wire_50 @TEXT("VSS", size=2.2, halign="middle", valign="baseline") => @PLACE(208.4, 26.4);
//   %p38 = (6.1, -72);
//   %wire_52 = &"DACN" @WIRE(mode="straight") {%p38 #"S_DACN":1};
//   %p39 = (109.6, -139.2);
//   %wire_53 = &"DACN" @WIRE(mode="straight") {%port_8:p %p39};
//   %wire_53 @TEXT("DACN", size=1.9, halign="middle", valign="baseline") => @PLACE(107.6, -139.2);
//   %wire_52 @TEXT("DACN", size=2.4, halign="end", valign="middle") => @PLACE(4.5, -72);
//   %p40 = (6.1, 0);
//   %wire_54 = &"DACP" @WIRE(mode="straight") {%p40 #"S_DACP":1};
//   %p41 = (74.4, -139.2);
//   %wire_55 = &"DACP" @WIRE(mode="straight") {%port_9:p %p41};
//   %wire_55 @TEXT("DACP", size=1.9, halign="middle", valign="baseline") => @PLACE(72.4, -139.2);
//   %wire_54 @TEXT("DACP", size=2.4, halign="end", valign="middle") => @PLACE(4.5, 0);
//   %p42 = (6.1, -48);
//   %wire_56 = &"VINN" @WIRE(mode="straight") {%p42 #"S_INN":1};
//   %p43 = (39.2, -139.2);
//   %wire_57 = &"VINN" @WIRE(mode="straight") {%port_10:p %p43};
//   %wire_57 @TEXT("VINN", size=1.9, halign="middle", valign="baseline") => @PLACE(37.2, -139.2);
//   %wire_56 @TEXT("VINN", size=2.4, halign="end", valign="middle") => @PLACE(4.5, -48);
//   %p44 = (6.1, 24);
//   %wire_58 = &"VINP" @WIRE(mode="straight") {%p44 #"S_INP":1};
//   %p45 = (4, -139.2);
//   %wire_59 = &"VINP" @WIRE(mode="straight") {%port_11:p %p45};
//   %wire_59 @TEXT("VINP", size=1.9, halign="middle", valign="baseline") => @PLACE(2, -139.2);
//   %wire_58 @TEXT("VINP", size=2.4, halign="end", valign="middle") => @PLACE(4.5, 24);
//   $JUNCTION @ATTACH %p1;
//   $JUNCTION @ATTACH %p2;
//   $JUNCTION @ATTACH %p4;
//   $JUNCTION @ATTACH %p5;
//   $JUNCTION @ATTACH %p8;
//   $JUNCTION @ATTACH %p10;
//   $JUNCTION @ATTACH %p14;
//   $JUNCTION @ATTACH %p19;
//   (0, 105.6) @TEXT("Vres = ROP-RON = 8 * (sampled input - coarse DAC)", size=3.2, halign="start", valign="baseline");
//   (73.6, 65.6) @TEXT("Cf = Cs1/8 = 187.5fF", size=2.9, halign="start", valign="baseline");
//   (0, 113.6) @TEXT("CLOSED-LOOP RESIDUE AMPLIFIER", size=4.8, halign="start", valign="baseline");
//   (0, -121.6) @TEXT("TRACK samples VINP/VINN; AMP connects DACP/DACN. RESET shorts Cf before amplification. BP/BN hold the sample.", size=2.9, halign="start", valign="baseline");
//   (163.2, -6.4) @TEXT("IDEAL OTA XP: non-inverting XN: inverting", size=2.9, halign="start", valign="baseline");
//   (48, 36.8) @TEXT("Cs1 = 1.5pF / side", size=2.9, halign="start", valign="baseline");
//   (0, -32) @TEXT("NEGATIVE INPUT BRANCH", size=2.9, halign="start", valign="baseline");
//   (0, -204.8) @TEXT("Native Switch Rseries: sample/reset=0.1ohm; DAC=5ohm Contact Ron=0.1ohm; standalone default Rseries=50ohm", size=2.9, halign="start", valign="baseline");
//   (0, 44.8) @TEXT("POSITIVE INPUT BRANCH", size=2.9, halign="start", valign="baseline");
//   (0, -132) @TEXT("INTERFACE PINS", size=2.9, halign="start", valign="baseline");
//   (168, 48) @TEXT("Clamp inside SC loop: 0..VDD 20mV margin / 100S finite clamp", size=2.9, halign="start", valign="baseline")
// }
ends PIPE_MDAC4_G8_SC
