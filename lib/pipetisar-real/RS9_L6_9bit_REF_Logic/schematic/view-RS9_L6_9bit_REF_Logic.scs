// Explicit native hierarchy assembly; no automatic inclusion.
simulator lang=spectre
include "RS9_L6_9bit_REF_Logic.scs"
