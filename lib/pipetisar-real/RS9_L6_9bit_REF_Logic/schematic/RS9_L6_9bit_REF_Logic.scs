// RNL cell 2026_PIPETISAR_RESEARCH/RS9_L6_9bit_REF_Logic
// @RNL(type="header") {
//   @VERSION("0.3");
//   @USE-PACKAGE(name="rnl-std-spectre", version="0.3", path="rnl-std-spectre.rnl");
//   @USE-PACKAGE(name="eda-symbol", version="0.1", path="eda-symbol.rnl");
//   @USE-PACKAGE(name="eda-style", version="0.1", path="eda-style.rnl")
// }
subckt RS9_L6_9bit_REF_Logic CLKT CLKTB DN_9 DN_8 DN_7 DN_6 DN_5 DN_4 DN_3 \
        DN_2 DN_1 DP_9 DP_8 DP_7 DP_6 DP_5 DP_4 DP_3 DP_2 DP_1 RNN_9 RNN_8 \
        RNN_7 RNN_6 RNN_5 RNN_4 RNN_3 RNN_2 RNN_1 RNP_9 RNP_8 RNP_7 RNP_6 \
        RNP_5 RNP_4 RNP_3 RNP_2 RNP_1 RPN_9 RPN_8 RPN_7 RPN_6 RPN_5 RPN_4 \
        RPN_3 RPN_2 RPN_1 RPP_9 RPP_8 RPP_7 RPP_6 RPP_5 RPP_4 RPP_3 RPP_2 \
        RPP_1 VDD VSS
    I32 (DN_8 CLKT RNN_8 VDD VSS) AN2D2BWP12T30P140LVT
    I12 (DP_8 CLKT RNP_8 VDD VSS) AN2D2BWP12T30P140LVT
    I19_5 (DP_5 CLKTB RPP_5 VDD VSS) OR2D0BWP12T30P140LVT
    I19_4 (DP_4 CLKTB RPP_4 VDD VSS) OR2D0BWP12T30P140LVT
    I19_3 (DP_3 CLKTB RPP_3 VDD VSS) OR2D0BWP12T30P140LVT
    I19_2 (DP_2 CLKTB RPP_2 VDD VSS) OR2D0BWP12T30P140LVT
    I19_1 (DP_1 CLKTB RPP_1 VDD VSS) OR2D0BWP12T30P140LVT
    I21_5 (DN_5 CLKTB RPN_5 VDD VSS) OR2D0BWP12T30P140LVT
    I21_4 (DN_4 CLKTB RPN_4 VDD VSS) OR2D0BWP12T30P140LVT
    I21_3 (DN_3 CLKTB RPN_3 VDD VSS) OR2D0BWP12T30P140LVT
    I21_2 (DN_2 CLKTB RPN_2 VDD VSS) OR2D0BWP12T30P140LVT
    I21_1 (DN_1 CLKTB RPN_1 VDD VSS) OR2D0BWP12T30P140LVT
    I18_5 (DP_5 CLKT RNP_5 VDD VSS) AN2D0BWP12T30P140LVT
    I18_4 (DP_4 CLKT RNP_4 VDD VSS) AN2D0BWP12T30P140LVT
    I18_3 (DP_3 CLKT RNP_3 VDD VSS) AN2D0BWP12T30P140LVT
    I18_2 (DP_2 CLKT RNP_2 VDD VSS) AN2D0BWP12T30P140LVT
    I18_1 (DP_1 CLKT RNP_1 VDD VSS) AN2D0BWP12T30P140LVT
    I20_5 (DN_5 CLKT RNN_5 VDD VSS) AN2D0BWP12T30P140LVT
    I20_4 (DN_4 CLKT RNN_4 VDD VSS) AN2D0BWP12T30P140LVT
    I20_3 (DN_3 CLKT RNN_3 VDD VSS) AN2D0BWP12T30P140LVT
    I20_2 (DN_2 CLKT RNN_2 VDD VSS) AN2D0BWP12T30P140LVT
    I20_1 (DN_1 CLKT RNN_1 VDD VSS) AN2D0BWP12T30P140LVT
    I33 (DN_8 CLKTB RPN_8 VDD VSS) OR2D2BWP12T30P140LVT
    I13 (DP_8 CLKTB RPP_8 VDD VSS) OR2D2BWP12T30P140LVT
    I4 (DN_7 CLKT RNN_7 VDD VSS) AN2D1BWP12T30P140LVT
    I10 (DP_7 CLKT RNP_7 VDD VSS) AN2D1BWP12T30P140LVT
    I17 (CLKTB DP_6 RNN_6 VDD VSS) NR2D0BWP12T30P140LVT
    I15 (CLKTB DN_6 RNP_6 VDD VSS) NR2D0BWP12T30P140LVT
    I5 (DN_7 CLKTB RPN_7 VDD VSS) OR2D1BWP12T30P140LVT
    I11 (DP_7 CLKTB RPP_7 VDD VSS) OR2D1BWP12T30P140LVT
    I16 (CLKT DN_6 RPP_6 VDD VSS) ND2D0BWP12T30P140LVT
    I14 (CLKT DP_6 RPN_6 VDD VSS) ND2D0BWP12T30P140LVT
    I29 (DP_9 CLKT RPN_9 VDD VSS) ND2D4BWP12T30P140LVT
    I34 (DN_9 CLKT RPP_9 VDD VSS) ND2D4BWP12T30P140LVT
    I31 (DP_9 CLKTB RNN_9 VDD VSS) NR2D4BWP12T30P140LVT
    I37 (DN_9 CLKTB RNP_9 VDD VSS) NR2D4BWP12T30P140LVT
// @RNL(author="rnl-virtuoso") {
//   %block_symbol = @DEFINE-SYMBOL(box=[4, -5, 18, 4]) {
//     @LINE {(0, -2) (4, -2)};
//     @LINE {(0, 0) (4, 0)};
//     @LINE {(22, -4) (18, -4)};
//     @LINE {(22, -2) (18, -2)};
//     @LINE {(22, 0) (18, 0)};
//     @LINE {(22, 2) (18, 2)};
//     @LINE {(10, 8) (10, 4)};
//     @LINE {(12, 8) (12, 4)};
//     @LINE {(10, -9) (10, -5)};
//     @LINE {(12, -9) (12, -5)};
//     @RECTANGLE {(4, -5) (18, 4)};
//     ? @TEXT("${name}", size=1, halign="start", valign="middle", key="name") => @PLACE(17, 5);
//     ? @TEXT("${model}", size=1, halign="middle", valign="middle", key="model") => @PLACE(11, 0);
//     (22, -2) @PIN(terminal=["RPN_9", "RPN_8", "RPN_7", "RPN_6", "RPN_5", "RPN_4", "RPN_3", "RPN_2", "RPN_1"]);
//     (26.4, -1) @TEXT("RPN<9:1>", size=1, halign="end", valign="middle");
//     (22, 0) @PIN(terminal=["RNP_9", "RNP_8", "RNP_7", "RNP_6", "RNP_5", "RNP_4", "RNP_3", "RNP_2", "RNP_1"]);
//     (26.4, 1) @TEXT("RNP<9:1>", size=1, halign="end", valign="middle");
//     (0, -2) @PIN(terminal=["DP_9", "DP_8", "DP_7", "DP_6", "DP_5", "DP_4", "DP_3", "DP_2", "DP_1"]);
//     (-2.4, -1) @TEXT("DP<9:1>", size=1, halign="start", valign="middle");
//     (22, 2) @PIN(terminal=["RNN_9", "RNN_8", "RNN_7", "RNN_6", "RNN_5", "RNN_4", "RNN_3", "RNN_2", "RNN_1"]);
//     (26.4, 3) @TEXT("RNN<9:1>", size=1, halign="end", valign="middle");
//     (0, 0) @PIN(terminal=["DN_9", "DN_8", "DN_7", "DN_6", "DN_5", "DN_4", "DN_3", "DN_2", "DN_1"]);
//     (-2.4, 1) @TEXT("DN<9:1>", size=1, halign="start", valign="middle");
//     (22, -4) @PIN(terminal=["RPP_9", "RPP_8", "RPP_7", "RPP_6", "RPP_5", "RPP_4", "RPP_3", "RPP_2", "RPP_1"]);
//     (26.4, -3) @TEXT("RPP<9:1>", size=1, halign="end", valign="middle");
//     (10, 8) @PIN(terminal="VDD");
//     (9, 7.4) @TEXT("VDD", size=1, halign="end", valign="middle", rotate=90);
//     (12, 8) @PIN(terminal="CLKT");
//     (11, 8.4) @TEXT("CLKT", size=1, halign="end", valign="middle", rotate=90);
//     (10, -9) @PIN(terminal="VSS");
//     (9, -8.4) @TEXT("VSS", size=1, halign="start", valign="middle", rotate=90);
//     (12, -9) @PIN(terminal="CLKTB");
//     (11, -9.4) @TEXT("CLKTB", size=1, halign="start", valign="middle", rotate=90)
//   };
//   # @SET-SYMBOL %block_symbol;
//   %symbol_0 = @DEFINE-SYMBOL(box=[8, -3, 17, 5]) {
//     (15.5, 1) @CIRCLE(radius=0.5);
//     @LINE {(12, 5) (12, 3)};
//     @LINE {(16, 1) (17, 1)};
//     @LINE {(12, -3) (12, -1)};
//     @LINE {(9, 3) (12, 3)};
//     @LINE {(9, -1) (12, -1)};
//     @ARC {(9, -1) (11, 1) (9, 3)};
//     @LINE {(8, 2) (10.7, 2)};
//     @LINE {(8, 0) (10.7, 0)};
//     @ARC {(14.9, 0.9) (13.8, 2.4) (12, 2.9)};
//     @ARC {(12, -1) (13.8, -0.5) (15, 1)};
//     ? @TEXT("${name}", size=0.4, halign="end", valign="top", key="name") => @PLACE(17, 5);
//     ? @TEXT("${model}", size=0.4, halign="end", valign="baseline", key="model") => @PLACE(17, -3);
//     (12, -3) @PIN(terminal=5);
//     (12.9, -3) @TEXT("VSS", size=0.4, halign="start", valign="middle");
//     (17, 1) @PIN(terminal=3);
//     (14.6, 1) @TEXT("ZN", size=0.4, halign="end", valign="middle");
//     (12, 5) @PIN(terminal=4);
//     (12.9, 5) @TEXT("VDD", size=0.4, halign="start", valign="middle");
//     (8, 2) @PIN(terminal=1);
//     (11.4, 2) @TEXT("A1", size=0.4, halign="start", valign="middle");
//     (8, 0) @PIN(terminal=2);
//     (11.4, 0) @TEXT("A2", size=0.4, halign="start", valign="middle")
//   };
//   #"I31" @SET-SYMBOL %symbol_0;
//   #"I31" @PLACE(-31, -10) => @ORIENT("R0");
//   %symbol_1 = @DEFINE-SYMBOL(box=[-6, -5, 2, 3]) {
//     @LINE {(-6, -2) (-4, -2)};
//     @LINE {(-6, 0) (-4, 0)};
//     @ARC {(-2, -3) (0, -1) (-2, 1)};
//     @LINE {(-4, -3) (-2, -3)};
//     @LINE {(-4, 1) (-2, 1)};
//     @LINE {(-4, 1) (-4, -3)};
//     @LINE {(-3, -5) (-3, -3)};
//     @LINE {(0, -1) (2, -1)};
//     @LINE {(-3, 3) (-3, 1)};
//     ? @TEXT("${model}", size=0.4, halign="end", valign="baseline", key="model") => @PLACE(2, -5);
//     ? @TEXT("${name}", size=0.4, halign="end", valign="top", key="name") => @PLACE(2, 3);
//     (-3, -5) @PIN(terminal=5);
//     (-2.1, -5) @TEXT("VSS", size=0.4, halign="start", valign="middle");
//     (-3, 3) @PIN(terminal=4);
//     (-2.1, 3) @TEXT("VDD", size=0.4, halign="start", valign="middle");
//     (2, -1) @PIN(terminal=3);
//     (-0.4, -1) @TEXT("Z", size=0.4, halign="end", valign="middle");
//     (-6, 0) @PIN(terminal=1);
//     (-3.6, 0) @TEXT("A1", size=0.4, halign="start", valign="middle");
//     (-6, -2) @PIN(terminal=2);
//     (-3.6, -2) @TEXT("A2", size=0.4, halign="start", valign="middle")
//   };
//   #"I10" @SET-SYMBOL %symbol_1;
//   #"I10" @PLACE(34, -51) => @ORIENT("R0");
//   %bundle_0 = {#"I20_5" #"I20_4" #"I20_3" #"I20_2" #"I20_1"} @BUNDLE;
//   %symbol_2 = @DEFINE-SYMBOL(box=[-6, -5, 2, 3]) {
//     @LINE {(-6, -2) (-4, -2)};
//     @LINE {(-6, 0) (-4, 0)};
//     @ARC {(-2, -3) (0, -1) (-2, 1)};
//     @LINE {(-4, -3) (-2, -3)};
//     @LINE {(-4, 1) (-2, 1)};
//     @LINE {(-4, 1) (-4, -3)};
//     @LINE {(-3, -5) (-3, -3)};
//     @LINE {(0, -1) (2, -1)};
//     @LINE {(-3, 3) (-3, 1)};
//     ? @TEXT("${model}", size=0.4, halign="end", valign="baseline", key="model") => @PLACE(2, -5);
//     ? @TEXT("${name}", size=0.4, halign="end", valign="top", key="name") => @PLACE(2, 3);
//     (-3, -5) @PIN(terminal=5);
//     (-2.1, -5) @TEXT("VSS", size=0.4, halign="start", valign="middle");
//     (-3, 3) @PIN(terminal=4);
//     (-2.1, 3) @TEXT("VDD", size=0.4, halign="start", valign="middle");
//     (2, -1) @PIN(terminal=3);
//     (-0.4, -1) @TEXT("Z", size=0.4, halign="end", valign="middle");
//     (-6, 0) @PIN(terminal=1);
//     (-3.6, 0) @TEXT("A1", size=0.4, halign="start", valign="middle");
//     (-6, -2) @PIN(terminal=2);
//     (-3.6, -2) @TEXT("A2", size=0.4, halign="start", valign="middle")
//   };
//   %bundle_0 @SET-SYMBOL %symbol_2;
//   %bundle_0 @PLACE(84, -8) => @ORIENT("R0");
//   %bundle_0 @TEXT("I20<5:1>", key="name");
//   %bundle_1 = {#"I19_5" #"I19_4" #"I19_3" #"I19_2" #"I19_1"} @BUNDLE;
//   %symbol_3 = @DEFINE-SYMBOL(box=[-1, -10, 8, -2]) {
//     @ARC {(3, -8) (4.8, -7.5) (6, -6)};
//     @ARC {(5.9, -6.1) (4.8, -4.6) (3, -4.1)};
//     @LINE {(-1, -7) (1.7, -7)};
//     @LINE {(-1, -5) (1.7, -5)};
//     @ARC {(0, -8) (2, -6) (0, -4)};
//     @LINE {(0, -8) (3, -8)};
//     @LINE {(0, -4) (3, -4)};
//     @LINE {(3, -10) (3, -8)};
//     @LINE {(6, -6) (7, -6)};
//     @LINE {(3, -2) (3, -4)};
//     @LINE {(7, -6) (8, -6)};
//     ? @TEXT("${name}", size=0.4, halign="end", valign="top", key="name") => @PLACE(8, -2);
//     ? @TEXT("${model}", size=0.4, halign="end", valign="baseline", key="model") => @PLACE(8, -10);
//     (3, -2) @PIN(terminal=4);
//     (3.9, -2) @TEXT("VDD", size=0.4, halign="start", valign="middle");
//     (8, -6) @PIN(terminal=3);
//     (5.6, -6) @TEXT("Z", size=0.4, halign="end", valign="middle");
//     (3, -10) @PIN(terminal=5);
//     (3.9, -10) @TEXT("VSS", size=0.4, halign="start", valign="middle");
//     (-1, -5) @PIN(terminal=1);
//     (2.4, -5) @TEXT("A1", size=0.4, halign="start", valign="middle");
//     (-1, -7) @PIN(terminal=2);
//     (2.4, -7) @TEXT("A2", size=0.4, halign="start", valign="middle")
//   };
//   %bundle_1 @SET-SYMBOL %symbol_3;
//   %bundle_1 @PLACE(78, -26) => @ORIENT("R0");
//   %bundle_1 @TEXT("I19<5:1>", key="name");
//   %symbol_4 = @DEFINE-SYMBOL(box=[-9, -3, 0, 5]) {
//     @LINE {(-6, 5) (-6, 3)};
//     @LINE {(-2, 1) (-1, 1)};
//     @LINE {(-6, -3) (-6, -1)};
//     @LINE {(-7, 3) (-7, -1)};
//     @LINE {(-7, 3) (-5, 3)};
//     @LINE {(-7, -1) (-5, -1)};
//     @ARC {(-5, -1) (-3, 1) (-5, 3)};
//     @LINE {(-9, 2) (-7, 2)};
//     @LINE {(-9, 0) (-7, 0)};
//     @LINE {(-1, 1) (0, 1)};
//     (-2.5, 1) @CIRCLE(radius=0.5);
//     ? @TEXT("${name}", size=0.4, halign="end", valign="top", key="name") => @PLACE(0, 5);
//     ? @TEXT("${model}", size=0.4, halign="end", valign="baseline", key="model") => @PLACE(0, -3);
//     (0, 1) @PIN(terminal=3);
//     (-3.4, 1) @TEXT("ZN", size=0.4, halign="end", valign="middle");
//     (-6, -3) @PIN(terminal=5);
//     (-5.1, -3) @TEXT("VSS", size=0.4, halign="start", valign="middle");
//     (-6, 5) @PIN(terminal=4);
//     (-5.1, 5) @TEXT("VDD", size=0.4, halign="start", valign="middle");
//     (-9, 2) @PIN(terminal=1);
//     (-6.6, 2) @TEXT("A1", size=0.4, halign="start", valign="middle");
//     (-9, 0) @PIN(terminal=2);
//     (-6.6, 0) @TEXT("A2", size=0.4, halign="start", valign="middle")
//   };
//   #"I29" @SET-SYMBOL %symbol_4;
//   #"I29" @PLACE(-13, 10) => @ORIENT("R0");
//   %symbol_5 = @DEFINE-SYMBOL(box=[-6, -5, 2, 3]) {
//     @LINE {(-6, -2) (-4, -2)};
//     @LINE {(-6, 0) (-4, 0)};
//     @ARC {(-2, -3) (0, -1) (-2, 1)};
//     @LINE {(-4, -3) (-2, -3)};
//     @LINE {(-4, 1) (-2, 1)};
//     @LINE {(-4, 1) (-4, -3)};
//     @LINE {(-3, -5) (-3, -3)};
//     @LINE {(0, -1) (2, -1)};
//     @LINE {(-3, 3) (-3, 1)};
//     ? @TEXT("${model}", size=0.4, halign="end", valign="baseline", key="model") => @PLACE(2, -5);
//     ? @TEXT("${name}", size=0.4, halign="end", valign="top", key="name") => @PLACE(2, 3);
//     (-3, -5) @PIN(terminal=5);
//     (-2.1, -5) @TEXT("VSS", size=0.4, halign="start", valign="middle");
//     (-3, 3) @PIN(terminal=4);
//     (-2.1, 3) @TEXT("VDD", size=0.4, halign="start", valign="middle");
//     (2, -1) @PIN(terminal=3);
//     (-0.4, -1) @TEXT("Z", size=0.4, halign="end", valign="middle");
//     (-6, 0) @PIN(terminal=1);
//     (-3.6, 0) @TEXT("A1", size=0.4, halign="start", valign="middle");
//     (-6, -2) @PIN(terminal=2);
//     (-3.6, -2) @TEXT("A2", size=0.4, halign="start", valign="middle")
//   };
//   #"I12" @SET-SYMBOL %symbol_5;
//   #"I12" @PLACE(11, -51) => @ORIENT("R0");
//   %symbol_6 = @DEFINE-SYMBOL(box=[-1, -10, 8, -2]) {
//     @ARC {(3, -8) (4.8, -7.5) (6, -6)};
//     @ARC {(5.9, -6.1) (4.8, -4.6) (3, -4.1)};
//     @LINE {(-1, -7) (1.7, -7)};
//     @LINE {(-1, -5) (1.7, -5)};
//     @ARC {(0, -8) (2, -6) (0, -4)};
//     @LINE {(0, -8) (3, -8)};
//     @LINE {(0, -4) (3, -4)};
//     @LINE {(3, -10) (3, -8)};
//     @LINE {(6, -6) (7, -6)};
//     @LINE {(3, -2) (3, -4)};
//     @LINE {(7, -6) (8, -6)};
//     ? @TEXT("${name}", size=0.4, halign="end", valign="top", key="name") => @PLACE(8, -2);
//     ? @TEXT("${model}", size=0.4, halign="end", valign="baseline", key="model") => @PLACE(8, -10);
//     (3, -2) @PIN(terminal=4);
//     (3.9, -2) @TEXT("VDD", size=0.4, halign="start", valign="middle");
//     (8, -6) @PIN(terminal=3);
//     (5.6, -6) @TEXT("Z", size=0.4, halign="end", valign="middle");
//     (3, -10) @PIN(terminal=5);
//     (3.9, -10) @TEXT("VSS", size=0.4, halign="start", valign="middle");
//     (-1, -5) @PIN(terminal=1);
//     (2.4, -5) @TEXT("A1", size=0.4, halign="start", valign="middle");
//     (-1, -7) @PIN(terminal=2);
//     (2.4, -7) @TEXT("A2", size=0.4, halign="start", valign="middle")
//   };
//   #"I5" @SET-SYMBOL %symbol_6;
//   #"I5" @PLACE(28, 17) => @ORIENT("R0");
//   %symbol_7 = @DEFINE-SYMBOL(box=[-1, -10, 8, -2]) {
//     @ARC {(3, -8) (4.8, -7.5) (6, -6)};
//     @ARC {(5.9, -6.1) (4.8, -4.6) (3, -4.1)};
//     @LINE {(-1, -7) (1.7, -7)};
//     @LINE {(-1, -5) (1.7, -5)};
//     @ARC {(0, -8) (2, -6) (0, -4)};
//     @LINE {(0, -8) (3, -8)};
//     @LINE {(0, -4) (3, -4)};
//     @LINE {(3, -10) (3, -8)};
//     @LINE {(6, -6) (7, -6)};
//     @LINE {(3, -2) (3, -4)};
//     @LINE {(7, -6) (8, -6)};
//     ? @TEXT("${name}", size=0.4, halign="end", valign="top", key="name") => @PLACE(8, -2);
//     ? @TEXT("${model}", size=0.4, halign="end", valign="baseline", key="model") => @PLACE(8, -10);
//     (3, -2) @PIN(terminal=4);
//     (3.9, -2) @TEXT("VDD", size=0.4, halign="start", valign="middle");
//     (8, -6) @PIN(terminal=3);
//     (5.6, -6) @TEXT("Z", size=0.4, halign="end", valign="middle");
//     (3, -10) @PIN(terminal=5);
//     (3.9, -10) @TEXT("VSS", size=0.4, halign="start", valign="middle");
//     (-1, -5) @PIN(terminal=1);
//     (2.4, -5) @TEXT("A1", size=0.4, halign="start", valign="middle");
//     (-1, -7) @PIN(terminal=2);
//     (2.4, -7) @TEXT("A2", size=0.4, halign="start", valign="middle")
//   };
//   #"I13" @SET-SYMBOL %symbol_7;
//   #"I13" @PLACE(5, -26) => @ORIENT("R0");
//   %symbol_8 = @DEFINE-SYMBOL(box=[-9, -3, 0, 5]) {
//     @LINE {(-6, 5) (-6, 3)};
//     @LINE {(-2, 1) (-1, 1)};
//     @LINE {(-6, -3) (-6, -1)};
//     @LINE {(-7, 3) (-7, -1)};
//     @LINE {(-7, 3) (-5, 3)};
//     @LINE {(-7, -1) (-5, -1)};
//     @ARC {(-5, -1) (-3, 1) (-5, 3)};
//     @LINE {(-9, 2) (-7, 2)};
//     @LINE {(-9, 0) (-7, 0)};
//     @LINE {(-1, 1) (0, 1)};
//     (-2.5, 1) @CIRCLE(radius=0.5);
//     ? @TEXT("${name}", size=0.4, halign="end", valign="top", key="name") => @PLACE(0, 5);
//     ? @TEXT("${model}", size=0.4, halign="end", valign="baseline", key="model") => @PLACE(0, -3);
//     (0, 1) @PIN(terminal=3);
//     (-3.4, 1) @TEXT("ZN", size=0.4, halign="end", valign="middle");
//     (-6, -3) @PIN(terminal=5);
//     (-5.1, -3) @TEXT("VSS", size=0.4, halign="start", valign="middle");
//     (-6, 5) @PIN(terminal=4);
//     (-5.1, 5) @TEXT("VDD", size=0.4, halign="start", valign="middle");
//     (-9, 2) @PIN(terminal=1);
//     (-6.6, 2) @TEXT("A1", size=0.4, halign="start", valign="middle");
//     (-9, 0) @PIN(terminal=2);
//     (-6.6, 0) @TEXT("A2", size=0.4, halign="start", valign="middle")
//   };
//   #"I16" @SET-SYMBOL %symbol_8;
//   #"I16" @PLACE(61, -33) => @ORIENT("R0");
//   %symbol_9 = @DEFINE-SYMBOL(box=[8, -3, 17, 5]) {
//     (15.5, 1) @CIRCLE(radius=0.5);
//     @LINE {(12, 5) (12, 3)};
//     @LINE {(16, 1) (17, 1)};
//     @LINE {(12, -3) (12, -1)};
//     @LINE {(9, 3) (12, 3)};
//     @LINE {(9, -1) (12, -1)};
//     @ARC {(9, -1) (11, 1) (9, 3)};
//     @LINE {(8, 2) (10.7, 2)};
//     @LINE {(8, 0) (10.7, 0)};
//     @ARC {(14.9, 0.9) (13.8, 2.4) (12, 2.9)};
//     @ARC {(12, -1) (13.8, -0.5) (15, 1)};
//     ? @TEXT("${name}", size=0.4, halign="end", valign="top", key="name") => @PLACE(17, 5);
//     ? @TEXT("${model}", size=0.4, halign="end", valign="baseline", key="model") => @PLACE(17, -3);
//     (12, -3) @PIN(terminal=5);
//     (12.9, -3) @TEXT("VSS", size=0.4, halign="start", valign="middle");
//     (17, 1) @PIN(terminal=3);
//     (14.6, 1) @TEXT("ZN", size=0.4, halign="end", valign="middle");
//     (12, 5) @PIN(terminal=4);
//     (12.9, 5) @TEXT("VDD", size=0.4, halign="start", valign="middle");
//     (8, 2) @PIN(terminal=1);
//     (11.4, 2) @TEXT("A1", size=0.4, halign="start", valign="middle");
//     (8, 0) @PIN(terminal=2);
//     (11.4, 0) @TEXT("A2", size=0.4, halign="start", valign="middle")
//   };
//   #"I15" @SET-SYMBOL %symbol_9;
//   #"I15" @PLACE(43, -53) => @ORIENT("R0");
//   #"I17" @SET-SYMBOL %symbol_9;
//   #"I17" @PLACE(43, -10) => @ORIENT("R0");
//   %bundle_2 = {#"I18_5" #"I18_4" #"I18_3" #"I18_2" #"I18_1"} @BUNDLE;
//   %bundle_2 @SET-SYMBOL %symbol_2;
//   %bundle_2 @PLACE(84, -51) => @ORIENT("R0");
//   %bundle_2 @TEXT("I18<5:1>", key="name");
//   %bundle_3 = {#"I21_5" #"I21_4" #"I21_3" #"I21_2" #"I21_1"} @BUNDLE;
//   %bundle_3 @SET-SYMBOL %symbol_3;
//   %bundle_3 @PLACE(78, 17) => @ORIENT("R0");
//   %bundle_3 @TEXT("I21<5:1>", key="name");
//   #"I4" @SET-SYMBOL %symbol_1;
//   #"I4" @PLACE(34, -8) => @ORIENT("R0");
//   #"I37" @SET-SYMBOL %symbol_0;
//   #"I37" @PLACE(-31, -53) => @ORIENT("R0");
//   #"I14" @SET-SYMBOL %symbol_8;
//   #"I14" @PLACE(61, 10) => @ORIENT("R0");
//   #"I33" @SET-SYMBOL %symbol_7;
//   #"I33" @PLACE(5, 17) => @ORIENT("R0");
//   #"I32" @SET-SYMBOL %symbol_5;
//   #"I32" @PLACE(11, -8) => @ORIENT("R0");
//   #"I34" @SET-SYMBOL %symbol_4;
//   #"I34" @PLACE(-13, -33) => @ORIENT("R0");
//   #"I11" @SET-SYMBOL %symbol_6;
//   #"I11" @PLACE(28, -26) => @ORIENT("R0");
//   %port_0 = $IO_PORT @ATTACH &"VDD" => @PLACE(-40, 13) => @ORIENT("R0");
//   %port_1 = $IO_PORT @ATTACH &"VSS" => @PLACE(-40, 10) => @ORIENT("R0");
//   %output_port_symbol = @DEFINE-SYMBOL(box=[0, -1, 2, 1]) {
//       @LINE(fill="linecolor", linestyle="none") {(0, -0.9) (0, 0.9) (1.1, 0.9) (2, 0) (1.1, -0.9) (0, -0.9)};
//       (0, 0) @PIN(terminal=1, direction="left");
//       ? @TEXT("${name}", key="name", halign="middle") => @PLACE(1, 1.6)
//     };
//   %bus_port_type_2 = @DEFINE(roles=[["p", "net"], ["p1", "net"], ["p2", "net"], ["p3", "net"], ["p4", "net"], ["p5", "net"], ["p6", "net"], ["p7", "net"], ["p8", "net"]]) {};
//   %bus_port_type_2_symbol = @DEFINE-SYMBOL {(0, 0) @PIN(terminal=[1, 2, 3, 4, 5, 6, 7, 8, 9])};
//   {&"RNN_9" &"RNN_8" &"RNN_7" &"RNN_6" &"RNN_5" &"RNN_4" &"RNN_3" &"RNN_2" &"RNN_1"} @REMOVE-FROM $PORT_FILL_SET;
//   %port_2 = %bus_port_type_2 @ATTACH &"RNN_9" &"RNN_8" &"RNN_7" &"RNN_6" &"RNN_5" &"RNN_4" &"RNN_3" &"RNN_2" &"RNN_1" => @PLACE(-41, -8) => @ORIENT("R0");
//   %port_2 @SET-SYMBOL %bus_port_type_2_symbol;
//   %port_2_marker = $IO_PORT @ATTACH &"RNN_9" => @PLACE(-41, -8) => @ORIENT("R0");
//   %port_2_marker @SET-SYMBOL %output_port_symbol;
//   %port_2_marker @TEXT("RNN<9:1>", key="name");
//   %bus_port_type_3 = @DEFINE(roles=[["p", "net"], ["p1", "net"], ["p2", "net"], ["p3", "net"], ["p4", "net"], ["p5", "net"], ["p6", "net"], ["p7", "net"], ["p8", "net"]]) {};
//   %bus_port_type_3_symbol = @DEFINE-SYMBOL {(0, 0) @PIN(terminal=[1, 2, 3, 4, 5, 6, 7, 8, 9])};
//   {&"RPP_9" &"RPP_8" &"RPP_7" &"RPP_6" &"RPP_5" &"RPP_4" &"RPP_3" &"RPP_2" &"RPP_1"} @REMOVE-FROM $PORT_FILL_SET;
//   %port_3 = %bus_port_type_3 @ATTACH &"RPP_9" &"RPP_8" &"RPP_7" &"RPP_6" &"RPP_5" &"RPP_4" &"RPP_3" &"RPP_2" &"RPP_1" => @PLACE(-41, -11) => @ORIENT("R0");
//   %port_3 @SET-SYMBOL %bus_port_type_3_symbol;
//   %port_3_marker = $IO_PORT @ATTACH &"RPP_9" => @PLACE(-41, -11) => @ORIENT("R0");
//   %port_3_marker @SET-SYMBOL %output_port_symbol;
//   %port_3_marker @TEXT("RPP<9:1>", key="name");
//   %input_port_symbol = @DEFINE-SYMBOL(box=[-2, -1, 0, 1]) {
//       @LINE(fill="linecolor", linestyle="none") {(-2, -0.9) (-2, 0.9) (-0.9, 0.9) (0, 0) (-0.9, -0.9) (-2, -0.9)};
//       (0, 0) @PIN(terminal=1, direction="right");
//       ? @TEXT("${name}", key="name", halign="middle") => @PLACE(-1, 1.6)
//     };
//   %port_4 = $IO_PORT @ATTACH &"CLKT" => @PLACE(-39, 1) => @ORIENT("R0");
//   %port_4 @SET-SYMBOL %input_port_symbol;
//   %port_4 @TEXT("CLKT", key="name");
//   %port_5 = $IO_PORT @ATTACH &"CLKTB" => @PLACE(-39, -2) => @ORIENT("R0");
//   %port_5 @SET-SYMBOL %input_port_symbol;
//   %port_5 @TEXT("CLKTB", key="name");
//   %bus_port_type_6 = @DEFINE(roles=[["p", "net"], ["p1", "net"], ["p2", "net"], ["p3", "net"], ["p4", "net"], ["p5", "net"], ["p6", "net"], ["p7", "net"], ["p8", "net"]]) {};
//   %bus_port_type_6_symbol = @DEFINE-SYMBOL {(0, 0) @PIN(terminal=[1, 2, 3, 4, 5, 6, 7, 8, 9])};
//   {&"RNP_9" &"RNP_8" &"RNP_7" &"RNP_6" &"RNP_5" &"RNP_4" &"RNP_3" &"RNP_2" &"RNP_1"} @REMOVE-FROM $PORT_FILL_SET;
//   %port_6 = %bus_port_type_6 @ATTACH &"RNP_9" &"RNP_8" &"RNP_7" &"RNP_6" &"RNP_5" &"RNP_4" &"RNP_3" &"RNP_2" &"RNP_1" => @PLACE(-41, -14) => @ORIENT("R0");
//   %port_6 @SET-SYMBOL %bus_port_type_6_symbol;
//   %port_6_marker = $IO_PORT @ATTACH &"RNP_9" => @PLACE(-41, -14) => @ORIENT("R0");
//   %port_6_marker @SET-SYMBOL %output_port_symbol;
//   %port_6_marker @TEXT("RNP<9:1>", key="name");
//   %bus_port_type_7 = @DEFINE(roles=[["p", "net"], ["p1", "net"], ["p2", "net"], ["p3", "net"], ["p4", "net"], ["p5", "net"], ["p6", "net"], ["p7", "net"], ["p8", "net"]]) {};
//   %bus_port_type_7_symbol = @DEFINE-SYMBOL {(0, 0) @PIN(terminal=[1, 2, 3, 4, 5, 6, 7, 8, 9])};
//   {&"DP_9" &"DP_8" &"DP_7" &"DP_6" &"DP_5" &"DP_4" &"DP_3" &"DP_2" &"DP_1"} @REMOVE-FROM $PORT_FILL_SET;
//   %port_7 = %bus_port_type_7 @ATTACH &"DP_9" &"DP_8" &"DP_7" &"DP_6" &"DP_5" &"DP_4" &"DP_3" &"DP_2" &"DP_1" => @PLACE(-39, 7) => @ORIENT("R0");
//   %port_7 @SET-SYMBOL %bus_port_type_7_symbol;
//   %port_7_marker = $IO_PORT @ATTACH &"DP_9" => @PLACE(-39, 7) => @ORIENT("R0");
//   %port_7_marker @SET-SYMBOL %input_port_symbol;
//   %port_7_marker @TEXT("DP<9:1>", key="name");
//   %bus_port_type_8 = @DEFINE(roles=[["p", "net"], ["p1", "net"], ["p2", "net"], ["p3", "net"], ["p4", "net"], ["p5", "net"], ["p6", "net"], ["p7", "net"], ["p8", "net"]]) {};
//   %bus_port_type_8_symbol = @DEFINE-SYMBOL {(0, 0) @PIN(terminal=[1, 2, 3, 4, 5, 6, 7, 8, 9])};
//   {&"RPN_9" &"RPN_8" &"RPN_7" &"RPN_6" &"RPN_5" &"RPN_4" &"RPN_3" &"RPN_2" &"RPN_1"} @REMOVE-FROM $PORT_FILL_SET;
//   %port_8 = %bus_port_type_8 @ATTACH &"RPN_9" &"RPN_8" &"RPN_7" &"RPN_6" &"RPN_5" &"RPN_4" &"RPN_3" &"RPN_2" &"RPN_1" => @PLACE(-41, -5) => @ORIENT("R0");
//   %port_8 @SET-SYMBOL %bus_port_type_8_symbol;
//   %port_8_marker = $IO_PORT @ATTACH &"RPN_9" => @PLACE(-41, -5) => @ORIENT("R0");
//   %port_8_marker @SET-SYMBOL %output_port_symbol;
//   %port_8_marker @TEXT("RPN<9:1>", key="name");
//   %bus_port_type_9 = @DEFINE(roles=[["p", "net"], ["p1", "net"], ["p2", "net"], ["p3", "net"], ["p4", "net"], ["p5", "net"], ["p6", "net"], ["p7", "net"], ["p8", "net"]]) {};
//   %bus_port_type_9_symbol = @DEFINE-SYMBOL {(0, 0) @PIN(terminal=[1, 2, 3, 4, 5, 6, 7, 8, 9])};
//   {&"DN_9" &"DN_8" &"DN_7" &"DN_6" &"DN_5" &"DN_4" &"DN_3" &"DN_2" &"DN_1"} @REMOVE-FROM $PORT_FILL_SET;
//   %port_9 = %bus_port_type_9 @ATTACH &"DN_9" &"DN_8" &"DN_7" &"DN_6" &"DN_5" &"DN_4" &"DN_3" &"DN_2" &"DN_1" => @PLACE(-39, 4) => @ORIENT("R0");
//   %port_9 @SET-SYMBOL %bus_port_type_9_symbol;
//   %port_9_marker = $IO_PORT @ATTACH &"DN_9" => @PLACE(-39, 4) => @ORIENT("R0");
//   %port_9_marker @SET-SYMBOL %input_port_symbol;
//   %port_9_marker @TEXT("DN<9:1>", key="name");
//   %p0 = (90, -32);
//   %wire_0 = {&"RPP_5" &"RPP_4" &"RPP_3" &"RPP_2" &"RPP_1"} @WIRE(mode="straight") {%bundle_1:3 %p0};
//   %wire_0 @TEXT("RPP<5:1>", size=1, halign="start", valign="baseline") => @PLACE(86.4, -31.3);
//   %p1 = (90, 11);
//   %wire_1 = {&"RPN_5" &"RPN_4" &"RPN_3" &"RPN_2" &"RPN_1"} @WIRE(mode="straight") {%bundle_3:3 %p1};
//   %wire_1 @TEXT("RPN<5:1>", size=1, halign="start", valign="baseline") => @PLACE(86.4, 11.7);
//   %p2 = (90, -52);
//   %wire_2 = {&"RNP_5" &"RNP_4" &"RNP_3" &"RNP_2" &"RNP_1"} @WIRE(mode="straight") {%bundle_2:3 %p2};
//   %wire_2 @TEXT("RNP<5:1>", size=1, halign="start", valign="baseline") => @PLACE(86.4, -51.3);
//   %p3 = (74, -51);
//   %wire_3 = {&"DP_5" &"DP_4" &"DP_3" &"DP_2" &"DP_1"} @WIRE(mode="straight") {%p3 %bundle_2:1};
//   %p4 = (73, -31);
//   %wire_4 = {&"DP_5" &"DP_4" &"DP_3" &"DP_2" &"DP_1"} @WIRE(mode="straight") {%p4 %bundle_1:1};
//   %wire_4 @TEXT("DP<5:1>", size=1, halign="end", valign="baseline") => @PLACE(76.6, -30.3);
//   %wire_3 @TEXT("DP<5:1>", size=1, halign="end", valign="baseline") => @PLACE(77.6, -50.3);
//   %p5 = (65, -52);
//   %wire_5 = &"RNP_6" @WIRE(mode="straight") {#"I15":3 %p5};
//   %wire_5 @TEXT("RNP\_6", size=1, halign="start", valign="baseline") => @PLACE(61.4, -51.3);
//   %p6 = (40, -52);
//   %wire_6 = &"RNP_7" @WIRE(mode="straight") {#"I10":3 %p6};
//   %wire_6 @TEXT("RNP\_7", size=1, halign="start", valign="baseline") => @PLACE(36.4, -51.3);
//   %p7 = (17, -52);
//   %wire_7 = &"RNP_8" @WIRE(mode="straight") {#"I12":3 %p7};
//   %wire_7 @TEXT("RNP\_8", size=1, halign="start", valign="baseline") => @PLACE(13.4, -51.3);
//   %p8 = (65, -32);
//   %wire_8 = &"RPP_6" @WIRE(mode="straight") {#"I16":3 %p8};
//   %wire_8 @TEXT("RPP\_6", size=1, halign="start", valign="baseline") => @PLACE(61.4, -31.3);
//   %p9 = (40, -32);
//   %wire_9 = &"RPP_7" @WIRE(mode="straight") {#"I11":3 %p9};
//   %wire_9 @TEXT("RPP\_7", size=1, halign="start", valign="baseline") => @PLACE(36.4, -31.3);
//   %p10 = (17, -32);
//   %wire_10 = &"RPP_8" @WIRE(mode="straight") {#"I13":3 %p10};
//   %wire_10 @TEXT("RPP\_8", size=1, halign="start", valign="baseline") => @PLACE(13.4, -31.3);
//   %p11 = (65, -9);
//   %wire_11 = &"RNN_6" @WIRE(mode="straight") {#"I17":3 %p11};
//   %wire_11 @TEXT("RNN\_6", size=1, halign="start", valign="baseline") => @PLACE(61.4, -8.3);
//   %p12 = (40, -9);
//   %wire_12 = &"RNN_7" @WIRE(mode="straight") {#"I4":3 %p12};
//   %wire_12 @TEXT("RNN\_7", size=1, halign="start", valign="baseline") => @PLACE(36.4, -8.3);
//   %p13 = (17, -9);
//   %wire_13 = &"RNN_8" @WIRE(mode="straight") {#"I32":3 %p13};
//   %wire_13 @TEXT("RNN\_8", size=1, halign="start", valign="baseline") => @PLACE(13.4, -8.3);
//   %p14 = (65, 11);
//   %wire_14 = &"RPN_6" @WIRE(mode="straight") {#"I14":3 %p14};
//   %wire_14 @TEXT("RPN\_6", size=1, halign="start", valign="baseline") => @PLACE(61.4, 11.7);
//   %p15 = (40, 11);
//   %wire_15 = &"RPN_7" @WIRE(mode="straight") {#"I5":3 %p15};
//   %wire_15 @TEXT("RPN\_7", size=1, halign="start", valign="baseline") => @PLACE(36.4, 11.7);
//   %p16 = (17, 11);
//   %wire_16 = &"RPN_8" @WIRE(mode="straight") {#"I33":3 %p16};
//   %wire_16 @TEXT("RPN\_8", size=1, halign="start", valign="baseline") => @PLACE(13.4, 11.7);
//   %p17 = (48, -33);
//   %wire_17 = &"DN_6" @WIRE(mode="straight") {%p17 #"I16":2};
//   %p18 = (47, -53);
//   %wire_18 = &"DN_6" @WIRE(mode="straight") {%p18 #"I15":2};
//   %wire_18 @TEXT("DN\_6", size=1, halign="end", valign="top") => @PLACE(50.6, -53.7);
//   %wire_17 @TEXT("DN\_6", size=1, halign="end", valign="top") => @PLACE(51.6, -33.7);
//   %p19 = (23, 12);
//   %wire_19 = &"DN_7" @WIRE(mode="straight") {%p19 #"I5":1};
//   %p20 = (24, -8);
//   %wire_20 = &"DN_7" @WIRE(mode="straight") {%p20 #"I4":1};
//   %wire_20 @TEXT("DN\_7", size=1, halign="end", valign="baseline") => @PLACE(27.6, -7.3);
//   %wire_19 @TEXT("DN\_7", size=1, halign="end", valign="baseline") => @PLACE(26.6, 12.7);
//   %p21 = (0, 12);
//   %wire_21 = &"DN_8" @WIRE(mode="straight") {%p21 #"I33":1};
//   %p22 = (1, -8);
//   %wire_22 = &"DN_8" @WIRE(mode="straight") {%p22 #"I32":1};
//   %wire_22 @TEXT("DN\_8", size=1, halign="end", valign="baseline") => @PLACE(4.6, -7.3);
//   %wire_21 @TEXT("DN\_8", size=1, halign="end", valign="baseline") => @PLACE(3.6, 12.7);
//   %p23 = (48, 10);
//   %wire_23 = &"DP_6" @WIRE(mode="straight") {%p23 #"I14":2};
//   %p24 = (47, -10);
//   %wire_24 = &"DP_6" @WIRE(mode="straight") {%p24 #"I17":2};
//   %wire_24 @TEXT("DP\_6", size=1, halign="end", valign="top") => @PLACE(50.6, -10.7);
//   %wire_23 @TEXT("DP\_6", size=1, halign="end", valign="top") => @PLACE(51.6, 9.3);
//   %p25 = (24, -51);
//   %wire_25 = &"DP_7" @WIRE(mode="straight") {%p25 #"I10":1};
//   %p26 = (23, -31);
//   %wire_26 = &"DP_7" @WIRE(mode="straight") {%p26 #"I11":1};
//   %wire_26 @TEXT("DP\_7", size=1, halign="end", valign="baseline") => @PLACE(26.6, -30.3);
//   %wire_25 @TEXT("DP\_7", size=1, halign="end", valign="baseline") => @PLACE(27.6, -50.3);
//   %p27 = (1, -51);
//   %wire_27 = &"DP_8" @WIRE(mode="straight") {%p27 #"I12":1};
//   %p28 = (0, -31);
//   %wire_28 = &"DP_8" @WIRE(mode="straight") {%p28 #"I13":1};
//   %wire_28 @TEXT("DP\_8", size=1, halign="end", valign="baseline") => @PLACE(3.6, -30.3);
//   %wire_27 @TEXT("DP\_8", size=1, halign="end", valign="baseline") => @PLACE(4.6, -50.3);
//   %p29 = (74, -8);
//   %wire_29 = {&"DN_5" &"DN_4" &"DN_3" &"DN_2" &"DN_1"} @WIRE(mode="straight") {%p29 %bundle_0:1};
//   %p30 = (73, 12);
//   %wire_30 = {&"DN_5" &"DN_4" &"DN_3" &"DN_2" &"DN_1"} @WIRE(mode="straight") {%p30 %bundle_3:1};
//   %wire_30 @TEXT("DN<5:1>", size=1, halign="end", valign="baseline") => @PLACE(76.6, 12.7);
//   %wire_29 @TEXT("DN<5:1>", size=1, halign="end", valign="baseline") => @PLACE(77.6, -7.3);
//   %p31 = (90, -9);
//   %wire_31 = {&"RNN_5" &"RNN_4" &"RNN_3" &"RNN_2" &"RNN_1"} @WIRE(mode="straight") {%bundle_0:3 %p31};
//   %wire_31 @TEXT("RNN<5:1>", size=1, halign="start", valign="baseline") => @PLACE(86.4, -8.3);
//   %p32 = (73, 10);
//   %wire_32 = &"CLKTB" @WIRE(mode="straight") {%p32 %bundle_3:2};
//   %p33 = (73, -33);
//   %wire_33 = &"CLKTB" @WIRE(mode="straight") {%p33 %bundle_1:2};
//   %p34 = (23, -33);
//   %wire_34 = &"CLKTB" @WIRE(mode="straight") {%p34 #"I11":2};
//   %p35 = (0, -33);
//   %wire_35 = &"CLKTB" @WIRE(mode="straight") {%p35 #"I13":2};
//   %p36 = (47, -8);
//   %wire_36 = &"CLKTB" @WIRE(mode="straight") {%p36 #"I17":1};
//   %p37 = (23, 10);
//   %wire_37 = &"CLKTB" @WIRE(mode="straight") {%p37 #"I5":2};
//   %p38 = (-27, -10);
//   %wire_38 = &"CLKTB" @WIRE(mode="straight") {%p38 #"I31":2};
//   %p39 = (0, 10);
//   %wire_39 = &"CLKTB" @WIRE(mode="straight") {%p39 #"I33":2};
//   %p40 = (-27, -53);
//   %wire_40 = &"CLKTB" @WIRE(mode="straight") {%p40 #"I37":2};
//   %p41 = (47, -51);
//   %wire_41 = &"CLKTB" @WIRE(mode="straight") {%p41 #"I15":1};
//   %wire_41 @TEXT("CLKTB", size=1, halign="end", valign="top") => @PLACE(50.6, -51.7);
//   %wire_40 @TEXT("CLKTB", size=1, halign="end", valign="baseline") => @PLACE(-23.4, -52.3);
//   %wire_39 @TEXT("CLKTB", size=1, halign="end", valign="baseline") => @PLACE(3.6, 10.7);
//   %wire_38 @TEXT("CLKTB", size=1, halign="end", valign="baseline") => @PLACE(-23.4, -9.3);
//   %wire_37 @TEXT("CLKTB", size=1, halign="end", valign="baseline") => @PLACE(26.6, 10.7);
//   %wire_36 @TEXT("CLKTB", size=1, halign="end", valign="top") => @PLACE(50.6, -8.7);
//   %wire_35 @TEXT("CLKTB", size=1, halign="end", valign="baseline") => @PLACE(3.6, -32.3);
//   %wire_34 @TEXT("CLKTB", size=1, halign="end", valign="baseline") => @PLACE(26.6, -32.3);
//   %wire_33 @TEXT("CLKTB", size=1, halign="end", valign="baseline") => @PLACE(76.6, -32.3);
//   %wire_32 @TEXT("CLKTB", size=1, halign="end", valign="baseline") => @PLACE(76.6, 10.7);
//   %p42 = (48, 12);
//   %wire_42 = &"CLKT" @WIRE(mode="straight") {%p42 #"I14":1};
//   %p43 = (74, -10);
//   %wire_43 = &"CLKT" @WIRE(mode="straight") {%p43 %bundle_0:2};
//   %p44 = (74, -53);
//   %wire_44 = &"CLKT" @WIRE(mode="straight") {%p44 %bundle_2:2};
//   %p45 = (24, -53);
//   %wire_45 = &"CLKT" @WIRE(mode="straight") {%p45 #"I10":2};
//   %p46 = (1, -53);
//   %wire_46 = &"CLKT" @WIRE(mode="straight") {%p46 #"I12":2};
//   %p47 = (24, -10);
//   %wire_47 = &"CLKT" @WIRE(mode="straight") {%p47 #"I4":2};
//   %p48 = (1, -10);
//   %wire_48 = &"CLKT" @WIRE(mode="straight") {%p48 #"I32":2};
//   %p49 = (-26, 10);
//   %wire_49 = &"CLKT" @WIRE(mode="straight") {%p49 #"I29":2};
//   %p50 = (48, -31);
//   %wire_50 = &"CLKT" @WIRE(mode="straight") {%p50 #"I16":1};
//   %p51 = (-26, -33);
//   %wire_51 = &"CLKT" @WIRE(mode="straight") {%p51 #"I34":2};
//   %wire_51 @TEXT("CLKT", size=1, halign="end", valign="baseline") => @PLACE(-22.4, -32.3);
//   %wire_50 @TEXT("CLKT", size=1, halign="end", valign="top") => @PLACE(51.6, -31.7);
//   %wire_49 @TEXT("CLKT", size=1, halign="end", valign="baseline") => @PLACE(-22.4, 10.7);
//   %wire_48 @TEXT("CLKT", size=1, halign="end", valign="baseline") => @PLACE(4.6, -9.3);
//   %wire_47 @TEXT("CLKT", size=1, halign="end", valign="baseline") => @PLACE(27.6, -9.3);
//   %wire_46 @TEXT("CLKT", size=1, halign="end", valign="baseline") => @PLACE(4.6, -52.3);
//   %wire_45 @TEXT("CLKT", size=1, halign="end", valign="baseline") => @PLACE(27.6, -52.3);
//   %wire_44 @TEXT("CLKT", size=1, halign="end", valign="baseline") => @PLACE(77.6, -52.3);
//   %wire_43 @TEXT("CLKT", size=1, halign="end", valign="baseline") => @PLACE(77.6, -9.3);
//   %wire_42 @TEXT("CLKT", size=1, halign="end", valign="top") => @PLACE(51.6, 11.3);
//   %p52 = (81, 3);
//   %wire_52 = &"VSS" @WIRE(mode="straight") {%p52 %bundle_3:5};
//   %p53 = (81, -17);
//   %wire_53 = &"VSS" @WIRE(mode="straight") {%p53 %bundle_0:5};
//   %p54 = (81, -60);
//   %wire_54 = &"VSS" @WIRE(mode="straight") {%p54 %bundle_2:5};
//   %p55 = (81, -40);
//   %wire_55 = &"VSS" @WIRE(mode="straight") {%p55 %bundle_1:5};
//   %p56 = (31, -40);
//   %wire_56 = &"VSS" @WIRE(mode="straight") {%p56 #"I11":5};
//   %p57 = (31, -60);
//   %wire_57 = &"VSS" @WIRE(mode="straight") {%p57 #"I10":5};
//   %p58 = (8, -60);
//   %wire_58 = &"VSS" @WIRE(mode="straight") {%p58 #"I12":5};
//   %p59 = (8, -40);
//   %wire_59 = &"VSS" @WIRE(mode="straight") {%p59 #"I13":5};
//   %p60 = (55, 3);
//   %wire_60 = &"VSS" @WIRE(mode="straight") {%p60 #"I14":5};
//   %p61 = (55, -17);
//   %wire_61 = &"VSS" @WIRE(mode="straight") {%p61 #"I17":5};
//   %p62 = (-19, 3);
//   %wire_62 = &"VSS" @WIRE(mode="straight") {%p62 #"I29":5};
//   %p63 = (31, -17);
//   %wire_63 = &"VSS" @WIRE(mode="straight") {%p63 #"I4":5};
//   %p64 = (31, 3);
//   %wire_64 = &"VSS" @WIRE(mode="straight") {%p64 #"I5":5};
//   %p65 = (-19, -17);
//   %wire_65 = &"VSS" @WIRE(mode="straight") {%p65 #"I31":5};
//   %p66 = (8, 3);
//   %wire_66 = &"VSS" @WIRE(mode="straight") {%p66 #"I33":5};
//   %p67 = (8, -17);
//   %wire_67 = &"VSS" @WIRE(mode="straight") {%p67 #"I32":5};
//   %p68 = (-19, -40);
//   %wire_68 = &"VSS" @WIRE(mode="straight") {%p68 #"I34":5};
//   %p69 = (-19, -60);
//   %wire_69 = &"VSS" @WIRE(mode="straight") {%p69 #"I37":5};
//   %p70 = (55, -40);
//   %wire_70 = &"VSS" @WIRE(mode="straight") {%p70 #"I16":5};
//   %p71 = (55, -60);
//   %wire_71 = &"VSS" @WIRE(mode="straight") {%p71 #"I15":5};
//   %wire_71 @TEXT("VSS", size=1, halign="end", valign="baseline", rotate=90) => @PLACE(54.3, -56.4);
//   %wire_70 @TEXT("VSS", size=1, halign="end", valign="baseline", rotate=90) => @PLACE(54.3, -36.4);
//   %wire_69 @TEXT("VSS", size=1, halign="end", valign="baseline", rotate=90) => @PLACE(-19.7, -56.4);
//   %wire_68 @TEXT("VSS", size=1, halign="end", valign="baseline", rotate=90) => @PLACE(-19.7, -36.4);
//   %wire_67 @TEXT("VSS", size=1, halign="end", valign="baseline", rotate=90) => @PLACE(7.3, -13.4);
//   %wire_66 @TEXT("VSS", size=1, halign="end", valign="baseline", rotate=90) => @PLACE(7.3, 6.6);
//   %wire_65 @TEXT("VSS", size=1, halign="end", valign="baseline", rotate=90) => @PLACE(-19.7, -13.4);
//   %wire_63 @TEXT("VSS", size=1, halign="end", valign="baseline", rotate=90) => @PLACE(30.3, -13.4);
//   %wire_62 @TEXT("VSS", size=1, halign="end", valign="baseline", rotate=90) => @PLACE(-19.7, 6.6);
//   %wire_64 @TEXT("VSS", size=1, halign="end", valign="baseline", rotate=90) => @PLACE(30.3, 6.6);
//   %wire_61 @TEXT("VSS", size=1, halign="end", valign="baseline", rotate=90) => @PLACE(54.3, -13.4);
//   %wire_60 @TEXT("VSS", size=1, halign="end", valign="baseline", rotate=90) => @PLACE(54.3, 6.6);
//   %wire_59 @TEXT("VSS", size=1, halign="end", valign="baseline", rotate=90) => @PLACE(7.3, -36.4);
//   %wire_58 @TEXT("VSS", size=1, halign="end", valign="baseline", rotate=90) => @PLACE(7.3, -56.4);
//   %wire_57 @TEXT("VSS", size=1, halign="end", valign="baseline", rotate=90) => @PLACE(30.3, -56.4);
//   %wire_56 @TEXT("VSS", size=1, halign="end", valign="baseline", rotate=90) => @PLACE(30.3, -36.4);
//   %wire_55 @TEXT("VSS", size=1, halign="end", valign="baseline", rotate=90) => @PLACE(80.3, -36.4);
//   %wire_54 @TEXT("VSS", size=1, halign="end", valign="baseline", rotate=90) => @PLACE(80.3, -56.4);
//   %wire_53 @TEXT("VSS", size=1, halign="end", valign="baseline", rotate=90) => @PLACE(80.3, -13.4);
//   %wire_52 @TEXT("VSS", size=1, halign="end", valign="baseline", rotate=90) => @PLACE(80.3, 6.6);
//   %p72 = (81, 19);
//   %wire_72 = &"VDD" @WIRE(mode="straight") {%bundle_3:4 %p72};
//   %p73 = (81, -1);
//   %wire_73 = &"VDD" @WIRE(mode="straight") {%bundle_0:4 %p73};
//   %p74 = (81, -44);
//   %wire_74 = &"VDD" @WIRE(mode="straight") {%bundle_2:4 %p74};
//   %p75 = (81, -24);
//   %wire_75 = &"VDD" @WIRE(mode="straight") {%bundle_1:4 %p75};
//   %p76 = (31, -24);
//   %wire_76 = &"VDD" @WIRE(mode="straight") {#"I11":4 %p76};
//   %p77 = (31, -44);
//   %wire_77 = &"VDD" @WIRE(mode="straight") {#"I10":4 %p77};
//   %p78 = (8, -44);
//   %wire_78 = &"VDD" @WIRE(mode="straight") {#"I12":4 %p78};
//   %p79 = (8, -24);
//   %wire_79 = &"VDD" @WIRE(mode="straight") {#"I13":4 %p79};
//   %p80 = (55, 19);
//   %wire_80 = &"VDD" @WIRE(mode="straight") {#"I14":4 %p80};
//   %p81 = (55, -1);
//   %wire_81 = &"VDD" @WIRE(mode="straight") {#"I17":4 %p81};
//   %p82 = (31, -1);
//   %wire_82 = &"VDD" @WIRE(mode="straight") {#"I4":4 %p82};
//   %p83 = (31, 19);
//   %wire_83 = &"VDD" @WIRE(mode="straight") {#"I5":4 %p83};
//   %p84 = (-19, 19);
//   %wire_84 = &"VDD" @WIRE(mode="straight") {#"I29":4 %p84};
//   %p85 = (-19, -1);
//   %wire_85 = &"VDD" @WIRE(mode="straight") {#"I31":4 %p85};
//   %p86 = (8, 19);
//   %wire_86 = &"VDD" @WIRE(mode="straight") {#"I33":4 %p86};
//   %p87 = (8, -1);
//   %wire_87 = &"VDD" @WIRE(mode="straight") {#"I32":4 %p87};
//   %p88 = (-19, -44);
//   %wire_88 = &"VDD" @WIRE(mode="straight") {#"I37":4 %p88};
//   %p89 = (-19, -24);
//   %wire_89 = &"VDD" @WIRE(mode="straight") {#"I34":4 %p89};
//   %p90 = (55, -44);
//   %wire_90 = &"VDD" @WIRE(mode="straight") {#"I15":4 %p90};
//   %p91 = (55, -24);
//   %wire_91 = &"VDD" @WIRE(mode="straight") {#"I16":4 %p91};
//   %wire_91 @TEXT("VDD", size=1, halign="start", valign="baseline", rotate=90) => @PLACE(54.3, -27.6);
//   %wire_90 @TEXT("VDD", size=1, halign="start", valign="baseline", rotate=90) => @PLACE(54.3, -47.6);
//   %wire_89 @TEXT("VDD", size=1, halign="start", valign="baseline", rotate=90) => @PLACE(-19.7, -27.6);
//   %wire_88 @TEXT("VDD", size=1, halign="start", valign="baseline", rotate=90) => @PLACE(-19.7, -47.6);
//   %wire_87 @TEXT("VDD", size=1, halign="start", valign="baseline", rotate=90) => @PLACE(7.3, -4.6);
//   %wire_86 @TEXT("VDD", size=1, halign="start", valign="baseline", rotate=90) => @PLACE(7.3, 15.4);
//   %wire_85 @TEXT("VDD", size=1, halign="start", valign="baseline", rotate=90) => @PLACE(-19.7, -4.6);
//   %wire_84 @TEXT("VDD", size=1, halign="start", valign="baseline", rotate=90) => @PLACE(-19.7, 15.4);
//   %wire_82 @TEXT("VDD", size=1, halign="start", valign="baseline", rotate=90) => @PLACE(30.3, -4.6);
//   %wire_83 @TEXT("VDD", size=1, halign="start", valign="baseline", rotate=90) => @PLACE(30.3, 15.4);
//   %wire_81 @TEXT("VDD", size=1, halign="start", valign="baseline", rotate=90) => @PLACE(54.3, -4.6);
//   %wire_80 @TEXT("VDD", size=1, halign="start", valign="baseline", rotate=90) => @PLACE(54.3, 15.4);
//   %wire_79 @TEXT("VDD", size=1, halign="start", valign="baseline", rotate=90) => @PLACE(7.3, -27.6);
//   %wire_78 @TEXT("VDD", size=1, halign="start", valign="baseline", rotate=90) => @PLACE(7.3, -47.6);
//   %wire_77 @TEXT("VDD", size=1, halign="start", valign="baseline", rotate=90) => @PLACE(30.3, -47.6);
//   %wire_76 @TEXT("VDD", size=1, halign="start", valign="baseline", rotate=90) => @PLACE(30.3, -27.6);
//   %wire_75 @TEXT("VDD", size=1, halign="start", valign="baseline", rotate=90) => @PLACE(80.3, -27.6);
//   %wire_74 @TEXT("VDD", size=1, halign="start", valign="baseline", rotate=90) => @PLACE(80.3, -47.6);
//   %wire_73 @TEXT("VDD", size=1, halign="start", valign="baseline", rotate=90) => @PLACE(80.3, -4.6);
//   %wire_72 @TEXT("VDD", size=1, halign="start", valign="baseline", rotate=90) => @PLACE(80.3, 15.4);
//   %p92 = (-26, 12);
//   %wire_92 = &"DP_9" @WIRE(mode="straight") {%p92 #"I29":1};
//   %p93 = (-27, -8);
//   %wire_93 = &"DP_9" @WIRE(mode="straight") {%p93 #"I31":1};
//   %wire_93 @TEXT("DP\_9", size=1, halign="end", valign="baseline") => @PLACE(-23.4, -7.3);
//   %wire_92 @TEXT("DP\_9", size=1, halign="end", valign="baseline") => @PLACE(-22.4, 12.7);
//   %p94 = (-26, -31);
//   %wire_94 = &"DN_9" @WIRE(mode="straight") {%p94 #"I34":1};
//   %p95 = (-27, -51);
//   %wire_95 = &"DN_9" @WIRE(mode="straight") {%p95 #"I37":1};
//   %wire_95 @TEXT("DN\_9", size=1, halign="end", valign="baseline") => @PLACE(-23.4, -50.3);
//   %wire_94 @TEXT("DN\_9", size=1, halign="end", valign="baseline") => @PLACE(-22.4, -30.3);
//   %p96 = (-9, 11);
//   %wire_96 = &"RPN_9" @WIRE(mode="straight") {#"I29":3 %p96};
//   %wire_96 @TEXT("RPN\_9", size=1, halign="start", valign="baseline") => @PLACE(-12.6, 11.7);
//   %p97 = (-9, -9);
//   %wire_97 = &"RNN_9" @WIRE(mode="straight") {#"I31":3 %p97};
//   %wire_97 @TEXT("RNN\_9", size=1, halign="start", valign="baseline") => @PLACE(-12.6, -8.3);
//   %p98 = (-9, -32);
//   %wire_98 = &"RPP_9" @WIRE(mode="straight") {#"I34":3 %p98};
//   %wire_98 @TEXT("RPP\_9", size=1, halign="start", valign="baseline") => @PLACE(-12.6, -31.3);
//   %p99 = (-9, -52);
//   %wire_99 = &"RNP_9" @WIRE(mode="straight") {#"I37":3 %p99};
//   %wire_99 @TEXT("RNP\_9", size=1, halign="start", valign="baseline") => @PLACE(-12.6, -51.3)
// }
ends RS9_L6_9bit_REF_Logic
