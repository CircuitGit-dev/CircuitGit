// RNL cell 2026_PIPETISAR_RESEARCH/L4_stage1_flash4_encoder
// @RNL(type="header") {
//   @VERSION("0.3");
//   @USE-PACKAGE(name="rnl-std-spectre", version="0.3", path="rnl-std-spectre.rnl");
//   @USE-PACKAGE(name="eda-symbol", version="0.1", path="eda-symbol.rnl");
//   @USE-PACKAGE(name="eda-style", version="0.1", path="eda-style.rnl")
// }
subckt L4_stage1_flash4_encoder BIN_3 BIN_2 BIN_1 BIN_0 D_14 D_13 D_12 \
        D_11 D_10 D_9 D_8 D_7 D_6 D_5 D_4 D_3 D_2 D_1 D_0 VDD VSS
    XN41 (N40 N40 VDD VSS BIN_3) ND2D0BWP12T30P140ULVT
    XN40 (D_7 D_7 VDD VSS N40) ND2D0BWP12T30P140ULVT
    XN39 (N37 N38 VDD VSS BIN_2) ND2D0BWP12T30P140ULVT
    XN38 (D_11 D_11 VDD VSS N38) ND2D0BWP12T30P140ULVT
    XN37 (D_3 N3 VDD VSS N37) ND2D0BWP12T30P140ULVT
    XN36 (N33 N35 VDD VSS BIN_1) ND2D0BWP12T30P140ULVT
    XN35 (N34 N34 VDD VSS N35) ND2D0BWP12T30P140ULVT
    XN34 (N30 N31 VDD VSS N34) ND2D0BWP12T30P140ULVT
    XN33 (N32 N32 VDD VSS N33) ND2D0BWP12T30P140ULVT
    XN32 (N28 N29 VDD VSS N32) ND2D0BWP12T30P140ULVT
    XN31 (D_13 D_13 VDD VSS N31) ND2D0BWP12T30P140ULVT
    XN30 (D_9 N5 VDD VSS N30) ND2D0BWP12T30P140ULVT
    XN29 (D_5 N3 VDD VSS N29) ND2D0BWP12T30P140ULVT
    XN28 (D_1 N1 VDD VSS N28) ND2D0BWP12T30P140ULVT
    XN27 (N24 N26 VDD VSS BIN_0) ND2D0BWP12T30P140ULVT
    XN26 (N25 N25 VDD VSS N26) ND2D0BWP12T30P140ULVT
    XN25 (N20 N22 VDD VSS N25) ND2D0BWP12T30P140ULVT
    XN24 (N23 N23 VDD VSS N24) ND2D0BWP12T30P140ULVT
    XN23 (N16 N18 VDD VSS N23) ND2D0BWP12T30P140ULVT
    XN22 (N21 N21 VDD VSS N22) ND2D0BWP12T30P140ULVT
    XN21 (N13 N14 VDD VSS N21) ND2D0BWP12T30P140ULVT
    XN20 (N19 N19 VDD VSS N20) ND2D0BWP12T30P140ULVT
    XN19 (N11 N12 VDD VSS N19) ND2D0BWP12T30P140ULVT
    XN18 (N17 N17 VDD VSS N18) ND2D0BWP12T30P140ULVT
    XN17 (N9 N10 VDD VSS N17) ND2D0BWP12T30P140ULVT
    XN16 (N15 N15 VDD VSS N16) ND2D0BWP12T30P140ULVT
    XN15 (N7 N8 VDD VSS N15) ND2D0BWP12T30P140ULVT
    XN14 (D_14 D_14 VDD VSS N14) ND2D0BWP12T30P140ULVT
    XN13 (D_12 N6 VDD VSS N13) ND2D0BWP12T30P140ULVT
    XN12 (D_10 N5 VDD VSS N12) ND2D0BWP12T30P140ULVT
    XN11 (D_8 N4 VDD VSS N11) ND2D0BWP12T30P140ULVT
    XN10 (D_6 N3 VDD VSS N10) ND2D0BWP12T30P140ULVT
    XN9 (D_4 N2 VDD VSS N9) ND2D0BWP12T30P140ULVT
    XN8 (D_2 N1 VDD VSS N8) ND2D0BWP12T30P140ULVT
    XN7 (D_0 N0 VDD VSS N7) ND2D0BWP12T30P140ULVT
    XN6 (D_13 D_13 VDD VSS N6) ND2D0BWP12T30P140ULVT
    XN5 (D_11 D_11 VDD VSS N5) ND2D0BWP12T30P140ULVT
    XN4 (D_9 D_9 VDD VSS N4) ND2D0BWP12T30P140ULVT
    XN3 (D_7 D_7 VDD VSS N3) ND2D0BWP12T30P140ULVT
    XN2 (D_5 D_5 VDD VSS N2) ND2D0BWP12T30P140ULVT
    XN1 (D_3 D_3 VDD VSS N1) ND2D0BWP12T30P140ULVT
    XN0 (D_1 D_1 VDD VSS N0) ND2D0BWP12T30P140ULVT
// @RNL(author="rnl-virtuoso") {
//   %block_symbol = @DEFINE-SYMBOL(box=[0, -4, 36, 8]) {
//     @LINE {(0, 0) (4, 0)};
//     @LINE {(36, 0) (32, 0)};
//     @LINE {(17, 8) (17, 4)};
//     @LINE {(19, 8) (19, 4)};
//     @RECTANGLE {(4, -4) (32, 4)};
//     ? @TEXT("${name}", size=1, halign="start", valign="middle", key="name") => @PLACE(32, 4);
//     ? @TEXT("${model}", size=1, halign="middle", valign="middle", key="model") => @PLACE(18, 0);
//     (0, 0) @PIN(terminal=["D_14", "D_13", "D_12", "D_11", "D_10", "D_9", "D_8", "D_7", "D_6", "D_5", "D_4", "D_3", "D_2", "D_1", "D_0"]);
//     (4.6, 0) @TEXT("D<14:0>", size=1, halign="start", valign="middle");
//     (36, 0) @PIN(terminal=["BIN_3", "BIN_2", "BIN_1", "BIN_0"]);
//     (31.4, 0) @TEXT("BIN<3:0>", size=1, halign="end", valign="middle");
//     (17, 8) @PIN(terminal="VSS");
//     (17, 3.4) @TEXT("VSS", size=1, halign="end", valign="middle", rotate=90);
//     (19, 8) @PIN(terminal="VDD");
//     (19, 3.4) @TEXT("VDD", size=1, halign="end", valign="middle", rotate=90)
//   };
//   # @SET-SYMBOL %block_symbol;
//   %symbol_0 = @DEFINE-SYMBOL(box=[-3, -4, 6, 4]) {
//     @LINE {(-1, -2) (1, -2)};
//     @LINE {(-1, 2) (1, 2)};
//     @LINE {(-3, 1) (-1, 1)};
//     @ARC {(1, -2) (3, 0) (1, 2)};
//     @LINE {(5, 0) (6, 0)};
//     @LINE {(-3, -1) (-1, -1)};
//     (3.5, 0) @CIRCLE(radius=0.5);
//     @LINE {(-1, 2) (-1, -2)};
//     @LINE {(0, -4) (0, -2)};
//     @LINE {(4, 0) (5, 0)};
//     @LINE {(0, 4) (0, 2)};
//     ? @TEXT("${model}", size=0.4, halign="end", valign="baseline", key="model") => @PLACE(6, -4);
//     ? @TEXT("${name}", size=0.4, halign="end", valign="top", key="name") => @PLACE(6, 4);
//     (0, -4) @PIN(terminal=4);
//     (0.9, -4) @TEXT("VSS", size=0.4, halign="start", valign="middle");
//     (6, 0) @PIN(terminal=5);
//     (2.6, 0) @TEXT("ZN", size=0.4, halign="end", valign="middle");
//     (-3, 1) @PIN(terminal=1);
//     (-0.6, 1) @TEXT("A1", size=0.4, halign="start", valign="middle");
//     (-3, -1) @PIN(terminal=2);
//     (-0.6, -1) @TEXT("A2", size=0.4, halign="start", valign="middle");
//     (0, 4) @PIN(terminal=3);
//     (0.9, 4) @TEXT("VDD", size=0.4, halign="start", valign="middle")
//   };
//   #"XN17" @SET-SYMBOL %symbol_0;
//   #"XN17" @PLACE(56, -96) => @ORIENT("R0");
//   #"XN39" @SET-SYMBOL %symbol_0;
//   #"XN39" @PLACE(392, -192) => @ORIENT("R0");
//   #"XN22" @SET-SYMBOL %symbol_0;
//   #"XN22" @PLACE(336, -96) => @ORIENT("R0");
//   #"XN37" @SET-SYMBOL %symbol_0;
//   #"XN37" @PLACE(280, -192) => @ORIENT("R0");
//   #"XN29" @SET-SYMBOL %symbol_0;
//   #"XN29" @PLACE(280, -144) => @ORIENT("R0");
//   #"XN34" @SET-SYMBOL %symbol_0;
//   #"XN34" @PLACE(112, -192) => @ORIENT("R0");
//   #"XN19" @SET-SYMBOL %symbol_0;
//   #"XN19" @PLACE(168, -96) => @ORIENT("R0");
//   #"XN12" @SET-SYMBOL %symbol_0;
//   #"XN12" @PLACE(224, -48) => @ORIENT("R0");
//   #"XN0" @SET-SYMBOL %symbol_0;
//   #"XN0" @PLACE(0, 0) => @ORIENT("R0");
//   #"XN30" @SET-SYMBOL %symbol_0;
//   #"XN30" @PLACE(336, -144) => @ORIENT("R0");
//   #"XN10" @SET-SYMBOL %symbol_0;
//   #"XN10" @PLACE(112, -48) => @ORIENT("R0");
//   #"XN6" @SET-SYMBOL %symbol_0;
//   #"XN6" @PLACE(336, 0) => @ORIENT("R0");
//   #"XN14" @SET-SYMBOL %symbol_0;
//   #"XN14" @PLACE(336, -48) => @ORIENT("R0");
//   #"XN20" @SET-SYMBOL %symbol_0;
//   #"XN20" @PLACE(224, -96) => @ORIENT("R0");
//   #"XN26" @SET-SYMBOL %symbol_0;
//   #"XN26" @PLACE(112, -144) => @ORIENT("R0");
//   #"XN15" @SET-SYMBOL %symbol_0;
//   #"XN15" @PLACE(392, -48) => @ORIENT("R0");
//   #"XN35" @SET-SYMBOL %symbol_0;
//   #"XN35" @PLACE(168, -192) => @ORIENT("R0");
//   #"XN24" @SET-SYMBOL %symbol_0;
//   #"XN24" @PLACE(0, -144) => @ORIENT("R0");
//   #"XN11" @SET-SYMBOL %symbol_0;
//   #"XN11" @PLACE(168, -48) => @ORIENT("R0");
//   #"XN31" @SET-SYMBOL %symbol_0;
//   #"XN31" @PLACE(392, -144) => @ORIENT("R0");
//   #"XN41" @SET-SYMBOL %symbol_0;
//   #"XN41" @PLACE(56, -240) => @ORIENT("R0");
//   #"XN40" @SET-SYMBOL %symbol_0;
//   #"XN40" @PLACE(0, -240) => @ORIENT("R0");
//   #"XN18" @SET-SYMBOL %symbol_0;
//   #"XN18" @PLACE(112, -96) => @ORIENT("R0");
//   #"XN33" @SET-SYMBOL %symbol_0;
//   #"XN33" @PLACE(56, -192) => @ORIENT("R0");
//   #"XN36" @SET-SYMBOL %symbol_0;
//   #"XN36" @PLACE(224, -192) => @ORIENT("R0");
//   #"XN2" @SET-SYMBOL %symbol_0;
//   #"XN2" @PLACE(112, 0) => @ORIENT("R0");
//   #"XN5" @SET-SYMBOL %symbol_0;
//   #"XN5" @PLACE(280, 0) => @ORIENT("R0");
//   #"XN23" @SET-SYMBOL %symbol_0;
//   #"XN23" @PLACE(392, -96) => @ORIENT("R0");
//   #"XN1" @SET-SYMBOL %symbol_0;
//   #"XN1" @PLACE(56, 0) => @ORIENT("R0");
//   #"XN13" @SET-SYMBOL %symbol_0;
//   #"XN13" @PLACE(280, -48) => @ORIENT("R0");
//   #"XN21" @SET-SYMBOL %symbol_0;
//   #"XN21" @PLACE(280, -96) => @ORIENT("R0");
//   #"XN7" @SET-SYMBOL %symbol_0;
//   #"XN7" @PLACE(392, 0) => @ORIENT("R0");
//   #"XN4" @SET-SYMBOL %symbol_0;
//   #"XN4" @PLACE(224, 0) => @ORIENT("R0");
//   #"XN16" @SET-SYMBOL %symbol_0;
//   #"XN16" @PLACE(0, -96) => @ORIENT("R0");
//   #"XN3" @SET-SYMBOL %symbol_0;
//   #"XN3" @PLACE(168, 0) => @ORIENT("R0");
//   #"XN25" @SET-SYMBOL %symbol_0;
//   #"XN25" @PLACE(56, -144) => @ORIENT("R0");
//   #"XN27" @SET-SYMBOL %symbol_0;
//   #"XN27" @PLACE(168, -144) => @ORIENT("R0");
//   #"XN28" @SET-SYMBOL %symbol_0;
//   #"XN28" @PLACE(224, -144) => @ORIENT("R0");
//   #"XN9" @SET-SYMBOL %symbol_0;
//   #"XN9" @PLACE(56, -48) => @ORIENT("R0");
//   #"XN8" @SET-SYMBOL %symbol_0;
//   #"XN8" @PLACE(0, -48) => @ORIENT("R0");
//   #"XN32" @SET-SYMBOL %symbol_0;
//   #"XN32" @PLACE(0, -192) => @ORIENT("R0");
//   #"XN38" @SET-SYMBOL %symbol_0;
//   #"XN38" @PLACE(336, -192) => @ORIENT("R0");
//   %input_port_symbol = @DEFINE-SYMBOL(box=[-2, -1, 0, 1]) {
//       @LINE(fill="linecolor", linestyle="none") {(-2, -0.9) (-2, 0.9) (-0.9, 0.9) (0, 0) (-0.9, -0.9) (-2, -0.9)};
//       (0, 0) @PIN(terminal=1, direction="right");
//       ? @TEXT("${name}", key="name", halign="middle") => @PLACE(-1, 1.6)
//     };
//   %bus_port_type_0 = @DEFINE(roles=[["p", "net"], ["p1", "net"], ["p2", "net"], ["p3", "net"], ["p4", "net"], ["p5", "net"], ["p6", "net"], ["p7", "net"], ["p8", "net"], ["p9", "net"], ["p10", "net"], ["p11", "net"], ["p12", "net"], ["p13", "net"], ["p14", "net"]]) {};
//   %bus_port_type_0_symbol = @DEFINE-SYMBOL {(0, 0) @PIN(terminal=[1, 2, 3, 4, 5, 6, 7, 8, 9, 10, 11, 12, 13, 14, 15])};
//   {&"D_14" &"D_13" &"D_12" &"D_11" &"D_10" &"D_9" &"D_8" &"D_7" &"D_6" &"D_5" &"D_4" &"D_3" &"D_2" &"D_1" &"D_0"} @REMOVE-FROM $PORT_FILL_SET;
//   %port_0 = %bus_port_type_0 @ATTACH &"D_14" &"D_13" &"D_12" &"D_11" &"D_10" &"D_9" &"D_8" &"D_7" &"D_6" &"D_5" &"D_4" &"D_3" &"D_2" &"D_1" &"D_0" => @PLACE(-64, 0) => @ORIENT("R0");
//   %port_0 @SET-SYMBOL %bus_port_type_0_symbol;
//   %port_0_marker = $IO_PORT @ATTACH &"D_14" => @PLACE(-64, 0) => @ORIENT("R0");
//   %port_0_marker @SET-SYMBOL %input_port_symbol;
//   %port_0_marker @TEXT("D<14:0>", key="name");
//   %output_port_symbol = @DEFINE-SYMBOL(box=[0, -1, 2, 1]) {
//       @LINE(fill="linecolor", linestyle="none") {(0, -0.9) (0, 0.9) (1.1, 0.9) (2, 0) (1.1, -0.9) (0, -0.9)};
//       (0, 0) @PIN(terminal=1, direction="left");
//       ? @TEXT("${name}", key="name", halign="middle") => @PLACE(1, 1.6)
//     };
//   %bus_port_type_1 = @DEFINE(roles=[["p", "net"], ["p1", "net"], ["p2", "net"], ["p3", "net"]]) {};
//   %bus_port_type_1_symbol = @DEFINE-SYMBOL {(0, 0) @PIN(terminal=[1, 2, 3, 4])};
//   {&"BIN_3" &"BIN_2" &"BIN_1" &"BIN_0"} @REMOVE-FROM $PORT_FILL_SET;
//   %port_1 = %bus_port_type_1 @ATTACH &"BIN_3" &"BIN_2" &"BIN_1" &"BIN_0" => @PLACE(-64, -8) => @ORIENT("R0");
//   %port_1 @SET-SYMBOL %bus_port_type_1_symbol;
//   %port_1_marker = $IO_PORT @ATTACH &"BIN_3" => @PLACE(-64, -8) => @ORIENT("R0");
//   %port_1_marker @SET-SYMBOL %output_port_symbol;
//   %port_1_marker @TEXT("BIN<3:0>", key="name");
//   %port_2 = $IO_PORT @ATTACH &"VDD" => @PLACE(-64, -16) => @ORIENT("R0");
//   %port_3 = $IO_PORT @ATTACH &"VSS" => @PLACE(-64, -24) => @ORIENT("R0");
//   %p0 = (45, -95);
//   %wire_0 = &"N9" @WIRE(mode="straight") {%p0 #"XN17":1};
//   %p1 = (70, -48);
//   %wire_1 = &"N9" @WIRE(mode="straight") {#"XN9":5 %p1};
//   %wire_1 @TEXT("N9", size=1, halign="middle", valign="baseline") => @PLACE(66, -48);
//   %wire_0 @TEXT("N9", size=1, halign="middle", valign="baseline") => @PLACE(49, -95);
//   %p2 = (381, -49);
//   %wire_2 = &"N8" @WIRE(mode="straight") {%p2 #"XN15":2};
//   %p3 = (14, -48);
//   %wire_3 = &"N8" @WIRE(mode="straight") {#"XN8":5 %p3};
//   %wire_3 @TEXT("N8", size=1, halign="middle", valign="baseline") => @PLACE(10, -48);
//   %wire_2 @TEXT("N8", size=1, halign="middle", valign="baseline") => @PLACE(385, -49);
//   %p4 = (381, -47);
//   %wire_4 = &"N7" @WIRE(mode="straight") {%p4 #"XN15":1};
//   %p5 = (406, 0);
//   %wire_5 = &"N7" @WIRE(mode="straight") {#"XN7":5 %p5};
//   %wire_5 @TEXT("N7", size=1, halign="middle", valign="baseline") => @PLACE(402, 0);
//   %wire_4 @TEXT("N7", size=1, halign="middle", valign="baseline") => @PLACE(385, -47);
//   %p6 = (269, -49);
//   %wire_6 = &"N6" @WIRE(mode="straight") {%p6 #"XN13":2};
//   %p7 = (350, 0);
//   %wire_7 = &"N6" @WIRE(mode="straight") {#"XN6":5 %p7};
//   %wire_7 @TEXT("N6", size=1, halign="middle", valign="baseline") => @PLACE(346, 0);
//   %wire_6 @TEXT("N6", size=1, halign="middle", valign="baseline") => @PLACE(273, -49);
//   %p8 = (325, -145);
//   %wire_8 = &"N5" @WIRE(mode="straight") {%p8 #"XN30":2};
//   %p9 = (213, -49);
//   %wire_9 = &"N5" @WIRE(mode="straight") {%p9 #"XN12":2};
//   %p10 = (294, 0);
//   %wire_10 = &"N5" @WIRE(mode="straight") {#"XN5":5 %p10};
//   %wire_10 @TEXT("N5", size=1, halign="middle", valign="baseline") => @PLACE(290, 0);
//   %wire_9 @TEXT("N5", size=1, halign="middle", valign="baseline") => @PLACE(217, -49);
//   %wire_8 @TEXT("N5", size=1, halign="middle", valign="baseline") => @PLACE(329, -145);
//   %p11 = (45, -241);
//   %wire_11 = &"N40" @WIRE(mode="straight") {%p11 #"XN41":2};
//   %p12 = (45, -239);
//   %wire_12 = &"N40" @WIRE(mode="straight") {%p12 #"XN41":1};
//   %p13 = (14, -240);
//   %wire_13 = &"N40" @WIRE(mode="straight") {#"XN40":5 %p13};
//   %wire_13 @TEXT("N40", size=1, halign="middle", valign="baseline") => @PLACE(10, -240);
//   %wire_12 @TEXT("N40", size=1, halign="middle", valign="baseline") => @PLACE(49, -239);
//   %wire_11 @TEXT("N40", size=1, halign="middle", valign="baseline") => @PLACE(49, -241);
//   %p14 = (157, -49);
//   %wire_14 = &"N4" @WIRE(mode="straight") {%p14 #"XN11":2};
//   %p15 = (238, 0);
//   %wire_15 = &"N4" @WIRE(mode="straight") {#"XN4":5 %p15};
//   %wire_15 @TEXT("N4", size=1, halign="middle", valign="baseline") => @PLACE(234, 0);
//   %wire_14 @TEXT("N4", size=1, halign="middle", valign="baseline") => @PLACE(161, -49);
//   %p16 = (381, -193);
//   %wire_16 = &"N38" @WIRE(mode="straight") {%p16 #"XN39":2};
//   %p17 = (350, -192);
//   %wire_17 = &"N38" @WIRE(mode="straight") {#"XN38":5 %p17};
//   %wire_17 @TEXT("N38", size=1, halign="middle", valign="baseline") => @PLACE(346, -192);
//   %wire_16 @TEXT("N38", size=1, halign="middle", valign="baseline") => @PLACE(385, -193);
//   %p18 = (381, -191);
//   %wire_18 = &"N37" @WIRE(mode="straight") {%p18 #"XN39":1};
//   %p19 = (294, -192);
//   %wire_19 = &"N37" @WIRE(mode="straight") {#"XN37":5 %p19};
//   %wire_19 @TEXT("N37", size=1, halign="middle", valign="baseline") => @PLACE(290, -192);
//   %wire_18 @TEXT("N37", size=1, halign="middle", valign="baseline") => @PLACE(385, -191);
//   %p20 = (213, -193);
//   %wire_20 = &"N35" @WIRE(mode="straight") {%p20 #"XN36":2};
//   %p21 = (182, -192);
//   %wire_21 = &"N35" @WIRE(mode="straight") {#"XN35":5 %p21};
//   %wire_21 @TEXT("N35", size=1, halign="middle", valign="baseline") => @PLACE(178, -192);
//   %wire_20 @TEXT("N35", size=1, halign="middle", valign="baseline") => @PLACE(217, -193);
//   %p22 = (157, -193);
//   %wire_22 = &"N34" @WIRE(mode="straight") {%p22 #"XN35":2};
//   %p23 = (157, -191);
//   %wire_23 = &"N34" @WIRE(mode="straight") {%p23 #"XN35":1};
//   %p24 = (126, -192);
//   %wire_24 = &"N34" @WIRE(mode="straight") {#"XN34":5 %p24};
//   %wire_24 @TEXT("N34", size=1, halign="middle", valign="baseline") => @PLACE(122, -192);
//   %wire_23 @TEXT("N34", size=1, halign="middle", valign="baseline") => @PLACE(161, -191);
//   %wire_22 @TEXT("N34", size=1, halign="middle", valign="baseline") => @PLACE(161, -193);
//   %p25 = (213, -191);
//   %wire_25 = &"N33" @WIRE(mode="straight") {%p25 #"XN36":1};
//   %p26 = (70, -192);
//   %wire_26 = &"N33" @WIRE(mode="straight") {#"XN33":5 %p26};
//   %wire_26 @TEXT("N33", size=1, halign="middle", valign="baseline") => @PLACE(66, -192);
//   %wire_25 @TEXT("N33", size=1, halign="middle", valign="baseline") => @PLACE(217, -191);
//   %p27 = (45, -193);
//   %wire_27 = &"N32" @WIRE(mode="straight") {%p27 #"XN33":2};
//   %p28 = (45, -191);
//   %wire_28 = &"N32" @WIRE(mode="straight") {%p28 #"XN33":1};
//   %p29 = (14, -192);
//   %wire_29 = &"N32" @WIRE(mode="straight") {#"XN32":5 %p29};
//   %wire_29 @TEXT("N32", size=1, halign="middle", valign="baseline") => @PLACE(10, -192);
//   %wire_28 @TEXT("N32", size=1, halign="middle", valign="baseline") => @PLACE(49, -191);
//   %wire_27 @TEXT("N32", size=1, halign="middle", valign="baseline") => @PLACE(49, -193);
//   %p30 = (101, -193);
//   %wire_30 = &"N31" @WIRE(mode="straight") {%p30 #"XN34":2};
//   %p31 = (406, -144);
//   %wire_31 = &"N31" @WIRE(mode="straight") {#"XN31":5 %p31};
//   %wire_31 @TEXT("N31", size=1, halign="middle", valign="baseline") => @PLACE(402, -144);
//   %wire_30 @TEXT("N31", size=1, halign="middle", valign="baseline") => @PLACE(105, -193);
//   %p32 = (101, -191);
//   %wire_32 = &"N30" @WIRE(mode="straight") {%p32 #"XN34":1};
//   %p33 = (350, -144);
//   %wire_33 = &"N30" @WIRE(mode="straight") {#"XN30":5 %p33};
//   %wire_33 @TEXT("N30", size=1, halign="middle", valign="baseline") => @PLACE(346, -144);
//   %wire_32 @TEXT("N30", size=1, halign="middle", valign="baseline") => @PLACE(105, -191);
//   %p34 = (269, -193);
//   %wire_34 = &"N3" @WIRE(mode="straight") {%p34 #"XN37":2};
//   %p35 = (269, -145);
//   %wire_35 = &"N3" @WIRE(mode="straight") {%p35 #"XN29":2};
//   %p36 = (101, -49);
//   %wire_36 = &"N3" @WIRE(mode="straight") {%p36 #"XN10":2};
//   %p37 = (182, 0);
//   %wire_37 = &"N3" @WIRE(mode="straight") {#"XN3":5 %p37};
//   %wire_37 @TEXT("N3", size=1, halign="middle", valign="baseline") => @PLACE(178, 0);
//   %wire_36 @TEXT("N3", size=1, halign="middle", valign="baseline") => @PLACE(105, -49);
//   %wire_35 @TEXT("N3", size=1, halign="middle", valign="baseline") => @PLACE(273, -145);
//   %wire_34 @TEXT("N3", size=1, halign="middle", valign="baseline") => @PLACE(273, -193);
//   %p38 = (-11, -193);
//   %wire_38 = &"N29" @WIRE(mode="straight") {%p38 #"XN32":2};
//   %p39 = (294, -144);
//   %wire_39 = &"N29" @WIRE(mode="straight") {#"XN29":5 %p39};
//   %wire_39 @TEXT("N29", size=1, halign="middle", valign="baseline") => @PLACE(290, -144);
//   %wire_38 @TEXT("N29", size=1, halign="middle", valign="baseline") => @PLACE(-7, -193);
//   %p40 = (-11, -191);
//   %wire_40 = &"N28" @WIRE(mode="straight") {%p40 #"XN32":1};
//   %p41 = (238, -144);
//   %wire_41 = &"N28" @WIRE(mode="straight") {#"XN28":5 %p41};
//   %wire_41 @TEXT("N28", size=1, halign="middle", valign="baseline") => @PLACE(234, -144);
//   %wire_40 @TEXT("N28", size=1, halign="middle", valign="baseline") => @PLACE(-7, -191);
//   %p42 = (157, -145);
//   %wire_42 = &"N26" @WIRE(mode="straight") {%p42 #"XN27":2};
//   %p43 = (126, -144);
//   %wire_43 = &"N26" @WIRE(mode="straight") {#"XN26":5 %p43};
//   %wire_43 @TEXT("N26", size=1, halign="middle", valign="baseline") => @PLACE(122, -144);
//   %wire_42 @TEXT("N26", size=1, halign="middle", valign="baseline") => @PLACE(161, -145);
//   %p44 = (101, -145);
//   %wire_44 = &"N25" @WIRE(mode="straight") {%p44 #"XN26":2};
//   %p45 = (101, -143);
//   %wire_45 = &"N25" @WIRE(mode="straight") {%p45 #"XN26":1};
//   %p46 = (70, -144);
//   %wire_46 = &"N25" @WIRE(mode="straight") {#"XN25":5 %p46};
//   %wire_46 @TEXT("N25", size=1, halign="middle", valign="baseline") => @PLACE(66, -144);
//   %wire_45 @TEXT("N25", size=1, halign="middle", valign="baseline") => @PLACE(105, -143);
//   %wire_44 @TEXT("N25", size=1, halign="middle", valign="baseline") => @PLACE(105, -145);
//   %p47 = (157, -143);
//   %wire_47 = &"N24" @WIRE(mode="straight") {%p47 #"XN27":1};
//   %p48 = (14, -144);
//   %wire_48 = &"N24" @WIRE(mode="straight") {#"XN24":5 %p48};
//   %wire_48 @TEXT("N24", size=1, halign="middle", valign="baseline") => @PLACE(10, -144);
//   %wire_47 @TEXT("N24", size=1, halign="middle", valign="baseline") => @PLACE(161, -143);
//   %p49 = (-11, -145);
//   %wire_49 = &"N23" @WIRE(mode="straight") {%p49 #"XN24":2};
//   %p50 = (-11, -143);
//   %wire_50 = &"N23" @WIRE(mode="straight") {%p50 #"XN24":1};
//   %p51 = (406, -96);
//   %wire_51 = &"N23" @WIRE(mode="straight") {#"XN23":5 %p51};
//   %wire_51 @TEXT("N23", size=1, halign="middle", valign="baseline") => @PLACE(402, -96);
//   %wire_50 @TEXT("N23", size=1, halign="middle", valign="baseline") => @PLACE(-7, -143);
//   %wire_49 @TEXT("N23", size=1, halign="middle", valign="baseline") => @PLACE(-7, -145);
//   %p52 = (45, -145);
//   %wire_52 = &"N22" @WIRE(mode="straight") {%p52 #"XN25":2};
//   %p53 = (350, -96);
//   %wire_53 = &"N22" @WIRE(mode="straight") {#"XN22":5 %p53};
//   %wire_53 @TEXT("N22", size=1, halign="middle", valign="baseline") => @PLACE(346, -96);
//   %wire_52 @TEXT("N22", size=1, halign="middle", valign="baseline") => @PLACE(49, -145);
//   %p54 = (325, -97);
//   %wire_54 = &"N21" @WIRE(mode="straight") {%p54 #"XN22":2};
//   %p55 = (325, -95);
//   %wire_55 = &"N21" @WIRE(mode="straight") {%p55 #"XN22":1};
//   %p56 = (294, -96);
//   %wire_56 = &"N21" @WIRE(mode="straight") {#"XN21":5 %p56};
//   %wire_56 @TEXT("N21", size=1, halign="middle", valign="baseline") => @PLACE(290, -96);
//   %wire_55 @TEXT("N21", size=1, halign="middle", valign="baseline") => @PLACE(329, -95);
//   %wire_54 @TEXT("N21", size=1, halign="middle", valign="baseline") => @PLACE(329, -97);
//   %p57 = (45, -143);
//   %wire_57 = &"N20" @WIRE(mode="straight") {%p57 #"XN25":1};
//   %p58 = (238, -96);
//   %wire_58 = &"N20" @WIRE(mode="straight") {#"XN20":5 %p58};
//   %wire_58 @TEXT("N20", size=1, halign="middle", valign="baseline") => @PLACE(234, -96);
//   %wire_57 @TEXT("N20", size=1, halign="middle", valign="baseline") => @PLACE(49, -143);
//   %p59 = (45, -49);
//   %wire_59 = &"N2" @WIRE(mode="straight") {%p59 #"XN9":2};
//   %p60 = (126, 0);
//   %wire_60 = &"N2" @WIRE(mode="straight") {#"XN2":5 %p60};
//   %wire_60 @TEXT("N2", size=1, halign="middle", valign="baseline") => @PLACE(122, 0);
//   %wire_59 @TEXT("N2", size=1, halign="middle", valign="baseline") => @PLACE(49, -49);
//   %p61 = (213, -97);
//   %wire_61 = &"N19" @WIRE(mode="straight") {%p61 #"XN20":2};
//   %p62 = (213, -95);
//   %wire_62 = &"N19" @WIRE(mode="straight") {%p62 #"XN20":1};
//   %p63 = (182, -96);
//   %wire_63 = &"N19" @WIRE(mode="straight") {#"XN19":5 %p63};
//   %wire_63 @TEXT("N19", size=1, halign="middle", valign="baseline") => @PLACE(178, -96);
//   %wire_62 @TEXT("N19", size=1, halign="middle", valign="baseline") => @PLACE(217, -95);
//   %wire_61 @TEXT("N19", size=1, halign="middle", valign="baseline") => @PLACE(217, -97);
//   %p64 = (381, -97);
//   %wire_64 = &"N18" @WIRE(mode="straight") {%p64 #"XN23":2};
//   %p65 = (126, -96);
//   %wire_65 = &"N18" @WIRE(mode="straight") {#"XN18":5 %p65};
//   %wire_65 @TEXT("N18", size=1, halign="middle", valign="baseline") => @PLACE(122, -96);
//   %wire_64 @TEXT("N18", size=1, halign="middle", valign="baseline") => @PLACE(385, -97);
//   %p66 = (101, -97);
//   %wire_66 = &"N17" @WIRE(mode="straight") {%p66 #"XN18":2};
//   %p67 = (101, -95);
//   %wire_67 = &"N17" @WIRE(mode="straight") {%p67 #"XN18":1};
//   %p68 = (70, -96);
//   %wire_68 = &"N17" @WIRE(mode="straight") {#"XN17":5 %p68};
//   %wire_68 @TEXT("N17", size=1, halign="middle", valign="baseline") => @PLACE(66, -96);
//   %wire_67 @TEXT("N17", size=1, halign="middle", valign="baseline") => @PLACE(105, -95);
//   %wire_66 @TEXT("N17", size=1, halign="middle", valign="baseline") => @PLACE(105, -97);
//   %p69 = (381, -95);
//   %wire_69 = &"N16" @WIRE(mode="straight") {%p69 #"XN23":1};
//   %p70 = (14, -96);
//   %wire_70 = &"N16" @WIRE(mode="straight") {#"XN16":5 %p70};
//   %wire_70 @TEXT("N16", size=1, halign="middle", valign="baseline") => @PLACE(10, -96);
//   %wire_69 @TEXT("N16", size=1, halign="middle", valign="baseline") => @PLACE(385, -95);
//   %p71 = (-11, -97);
//   %wire_71 = &"N15" @WIRE(mode="straight") {%p71 #"XN16":2};
//   %p72 = (-11, -95);
//   %wire_72 = &"N15" @WIRE(mode="straight") {%p72 #"XN16":1};
//   %p73 = (406, -48);
//   %wire_73 = &"N15" @WIRE(mode="straight") {#"XN15":5 %p73};
//   %wire_73 @TEXT("N15", size=1, halign="middle", valign="baseline") => @PLACE(402, -48);
//   %wire_72 @TEXT("N15", size=1, halign="middle", valign="baseline") => @PLACE(-7, -95);
//   %wire_71 @TEXT("N15", size=1, halign="middle", valign="baseline") => @PLACE(-7, -97);
//   %p74 = (269, -97);
//   %wire_74 = &"N14" @WIRE(mode="straight") {%p74 #"XN21":2};
//   %p75 = (350, -48);
//   %wire_75 = &"N14" @WIRE(mode="straight") {#"XN14":5 %p75};
//   %wire_75 @TEXT("N14", size=1, halign="middle", valign="baseline") => @PLACE(346, -48);
//   %wire_74 @TEXT("N14", size=1, halign="middle", valign="baseline") => @PLACE(273, -97);
//   %p76 = (269, -95);
//   %wire_76 = &"N13" @WIRE(mode="straight") {%p76 #"XN21":1};
//   %p77 = (294, -48);
//   %wire_77 = &"N13" @WIRE(mode="straight") {#"XN13":5 %p77};
//   %wire_77 @TEXT("N13", size=1, halign="middle", valign="baseline") => @PLACE(290, -48);
//   %wire_76 @TEXT("N13", size=1, halign="middle", valign="baseline") => @PLACE(273, -95);
//   %p78 = (157, -97);
//   %wire_78 = &"N12" @WIRE(mode="straight") {%p78 #"XN19":2};
//   %p79 = (238, -48);
//   %wire_79 = &"N12" @WIRE(mode="straight") {#"XN12":5 %p79};
//   %wire_79 @TEXT("N12", size=1, halign="middle", valign="baseline") => @PLACE(234, -48);
//   %wire_78 @TEXT("N12", size=1, halign="middle", valign="baseline") => @PLACE(161, -97);
//   %p80 = (157, -95);
//   %wire_80 = &"N11" @WIRE(mode="straight") {%p80 #"XN19":1};
//   %p81 = (182, -48);
//   %wire_81 = &"N11" @WIRE(mode="straight") {#"XN11":5 %p81};
//   %wire_81 @TEXT("N11", size=1, halign="middle", valign="baseline") => @PLACE(178, -48);
//   %wire_80 @TEXT("N11", size=1, halign="middle", valign="baseline") => @PLACE(161, -95);
//   %p82 = (45, -97);
//   %wire_82 = &"N10" @WIRE(mode="straight") {%p82 #"XN17":2};
//   %p83 = (126, -48);
//   %wire_83 = &"N10" @WIRE(mode="straight") {#"XN10":5 %p83};
//   %wire_83 @TEXT("N10", size=1, halign="middle", valign="baseline") => @PLACE(122, -48);
//   %wire_82 @TEXT("N10", size=1, halign="middle", valign="baseline") => @PLACE(49, -97);
//   %p84 = (213, -145);
//   %wire_84 = &"N1" @WIRE(mode="straight") {%p84 #"XN28":2};
//   %p85 = (-11, -49);
//   %wire_85 = &"N1" @WIRE(mode="straight") {%p85 #"XN8":2};
//   %p86 = (70, 0);
//   %wire_86 = &"N1" @WIRE(mode="straight") {#"XN1":5 %p86};
//   %wire_86 @TEXT("N1", size=1, halign="middle", valign="baseline") => @PLACE(66, 0);
//   %wire_85 @TEXT("N1", size=1, halign="middle", valign="baseline") => @PLACE(-7, -49);
//   %wire_84 @TEXT("N1", size=1, halign="middle", valign="baseline") => @PLACE(217, -145);
//   %p87 = (381, -1);
//   %wire_87 = &"N0" @WIRE(mode="straight") {%p87 #"XN7":2};
//   %p88 = (14, 0);
//   %wire_88 = &"N0" @WIRE(mode="straight") {#"XN0":5 %p88};
//   %wire_88 @TEXT("N0", size=1, halign="middle", valign="baseline") => @PLACE(10, 0);
//   %wire_87 @TEXT("N0", size=1, halign="middle", valign="baseline") => @PLACE(385, -1);
//   %p89 = (-57.6, -24);
//   %wire_89 = &"VSS" @WIRE(mode="straight") {%port_3:p %p89};
//   %p90 = (56, -252);
//   %wire_90 = &"VSS" @WIRE(mode="straight") {%p90 #"XN41":4};
//   %p91 = (0, -252);
//   %wire_91 = &"VSS" @WIRE(mode="straight") {%p91 #"XN40":4};
//   %p92 = (392, -204);
//   %wire_92 = &"VSS" @WIRE(mode="straight") {%p92 #"XN39":4};
//   %p93 = (336, -204);
//   %wire_93 = &"VSS" @WIRE(mode="straight") {%p93 #"XN38":4};
//   %p94 = (280, -204);
//   %wire_94 = &"VSS" @WIRE(mode="straight") {%p94 #"XN37":4};
//   %p95 = (224, -204);
//   %wire_95 = &"VSS" @WIRE(mode="straight") {%p95 #"XN36":4};
//   %p96 = (168, -204);
//   %wire_96 = &"VSS" @WIRE(mode="straight") {%p96 #"XN35":4};
//   %p97 = (112, -204);
//   %wire_97 = &"VSS" @WIRE(mode="straight") {%p97 #"XN34":4};
//   %p98 = (56, -204);
//   %wire_98 = &"VSS" @WIRE(mode="straight") {%p98 #"XN33":4};
//   %p99 = (0, -204);
//   %wire_99 = &"VSS" @WIRE(mode="straight") {%p99 #"XN32":4};
//   %p100 = (392, -156);
//   %wire_100 = &"VSS" @WIRE(mode="straight") {%p100 #"XN31":4};
//   %p101 = (336, -156);
//   %wire_101 = &"VSS" @WIRE(mode="straight") {%p101 #"XN30":4};
//   %p102 = (280, -156);
//   %wire_102 = &"VSS" @WIRE(mode="straight") {%p102 #"XN29":4};
//   %p103 = (224, -156);
//   %wire_103 = &"VSS" @WIRE(mode="straight") {%p103 #"XN28":4};
//   %p104 = (168, -156);
//   %wire_104 = &"VSS" @WIRE(mode="straight") {%p104 #"XN27":4};
//   %p105 = (112, -156);
//   %wire_105 = &"VSS" @WIRE(mode="straight") {%p105 #"XN26":4};
//   %p106 = (56, -156);
//   %wire_106 = &"VSS" @WIRE(mode="straight") {%p106 #"XN25":4};
//   %p107 = (0, -156);
//   %wire_107 = &"VSS" @WIRE(mode="straight") {%p107 #"XN24":4};
//   %p108 = (392, -108);
//   %wire_108 = &"VSS" @WIRE(mode="straight") {%p108 #"XN23":4};
//   %p109 = (336, -108);
//   %wire_109 = &"VSS" @WIRE(mode="straight") {%p109 #"XN22":4};
//   %p110 = (280, -108);
//   %wire_110 = &"VSS" @WIRE(mode="straight") {%p110 #"XN21":4};
//   %p111 = (224, -108);
//   %wire_111 = &"VSS" @WIRE(mode="straight") {%p111 #"XN20":4};
//   %p112 = (168, -108);
//   %wire_112 = &"VSS" @WIRE(mode="straight") {%p112 #"XN19":4};
//   %p113 = (112, -108);
//   %wire_113 = &"VSS" @WIRE(mode="straight") {%p113 #"XN18":4};
//   %p114 = (56, -108);
//   %wire_114 = &"VSS" @WIRE(mode="straight") {%p114 #"XN17":4};
//   %p115 = (0, -108);
//   %wire_115 = &"VSS" @WIRE(mode="straight") {%p115 #"XN16":4};
//   %p116 = (392, -60);
//   %wire_116 = &"VSS" @WIRE(mode="straight") {%p116 #"XN15":4};
//   %p117 = (336, -60);
//   %wire_117 = &"VSS" @WIRE(mode="straight") {%p117 #"XN14":4};
//   %p118 = (280, -60);
//   %wire_118 = &"VSS" @WIRE(mode="straight") {%p118 #"XN13":4};
//   %p119 = (224, -60);
//   %wire_119 = &"VSS" @WIRE(mode="straight") {%p119 #"XN12":4};
//   %p120 = (168, -60);
//   %wire_120 = &"VSS" @WIRE(mode="straight") {%p120 #"XN11":4};
//   %p121 = (112, -60);
//   %wire_121 = &"VSS" @WIRE(mode="straight") {%p121 #"XN10":4};
//   %p122 = (56, -60);
//   %wire_122 = &"VSS" @WIRE(mode="straight") {%p122 #"XN9":4};
//   %p123 = (0, -60);
//   %wire_123 = &"VSS" @WIRE(mode="straight") {%p123 #"XN8":4};
//   %p124 = (392, -12);
//   %wire_124 = &"VSS" @WIRE(mode="straight") {%p124 #"XN7":4};
//   %p125 = (336, -12);
//   %wire_125 = &"VSS" @WIRE(mode="straight") {%p125 #"XN6":4};
//   %p126 = (280, -12);
//   %wire_126 = &"VSS" @WIRE(mode="straight") {%p126 #"XN5":4};
//   %p127 = (224, -12);
//   %wire_127 = &"VSS" @WIRE(mode="straight") {%p127 #"XN4":4};
//   %p128 = (168, -12);
//   %wire_128 = &"VSS" @WIRE(mode="straight") {%p128 #"XN3":4};
//   %p129 = (112, -12);
//   %wire_129 = &"VSS" @WIRE(mode="straight") {%p129 #"XN2":4};
//   %p130 = (56, -12);
//   %wire_130 = &"VSS" @WIRE(mode="straight") {%p130 #"XN1":4};
//   %p131 = (0, -12);
//   %wire_131 = &"VSS" @WIRE(mode="straight") {%p131 #"XN0":4};
//   %wire_131 @TEXT("VSS", size=1, halign="middle", valign="baseline") => @PLACE(0, -8);
//   %wire_130 @TEXT("VSS", size=1, halign="middle", valign="baseline") => @PLACE(56, -8);
//   %wire_129 @TEXT("VSS", size=1, halign="middle", valign="baseline") => @PLACE(112, -8);
//   %wire_128 @TEXT("VSS", size=1, halign="middle", valign="baseline") => @PLACE(168, -8);
//   %wire_127 @TEXT("VSS", size=1, halign="middle", valign="baseline") => @PLACE(224, -8);
//   %wire_126 @TEXT("VSS", size=1, halign="middle", valign="baseline") => @PLACE(280, -8);
//   %wire_125 @TEXT("VSS", size=1, halign="middle", valign="baseline") => @PLACE(336, -8);
//   %wire_124 @TEXT("VSS", size=1, halign="middle", valign="baseline") => @PLACE(392, -8);
//   %wire_123 @TEXT("VSS", size=1, halign="middle", valign="baseline") => @PLACE(0, -56);
//   %wire_122 @TEXT("VSS", size=1, halign="middle", valign="baseline") => @PLACE(56, -56);
//   %wire_121 @TEXT("VSS", size=1, halign="middle", valign="baseline") => @PLACE(112, -56);
//   %wire_120 @TEXT("VSS", size=1, halign="middle", valign="baseline") => @PLACE(168, -56);
//   %wire_119 @TEXT("VSS", size=1, halign="middle", valign="baseline") => @PLACE(224, -56);
//   %wire_118 @TEXT("VSS", size=1, halign="middle", valign="baseline") => @PLACE(280, -56);
//   %wire_117 @TEXT("VSS", size=1, halign="middle", valign="baseline") => @PLACE(336, -56);
//   %wire_116 @TEXT("VSS", size=1, halign="middle", valign="baseline") => @PLACE(392, -56);
//   %wire_115 @TEXT("VSS", size=1, halign="middle", valign="baseline") => @PLACE(0, -104);
//   %wire_114 @TEXT("VSS", size=1, halign="middle", valign="baseline") => @PLACE(56, -104);
//   %wire_113 @TEXT("VSS", size=1, halign="middle", valign="baseline") => @PLACE(112, -104);
//   %wire_112 @TEXT("VSS", size=1, halign="middle", valign="baseline") => @PLACE(168, -104);
//   %wire_111 @TEXT("VSS", size=1, halign="middle", valign="baseline") => @PLACE(224, -104);
//   %wire_110 @TEXT("VSS", size=1, halign="middle", valign="baseline") => @PLACE(280, -104);
//   %wire_109 @TEXT("VSS", size=1, halign="middle", valign="baseline") => @PLACE(336, -104);
//   %wire_108 @TEXT("VSS", size=1, halign="middle", valign="baseline") => @PLACE(392, -104);
//   %wire_107 @TEXT("VSS", size=1, halign="middle", valign="baseline") => @PLACE(0, -152);
//   %wire_106 @TEXT("VSS", size=1, halign="middle", valign="baseline") => @PLACE(56, -152);
//   %wire_105 @TEXT("VSS", size=1, halign="middle", valign="baseline") => @PLACE(112, -152);
//   %wire_104 @TEXT("VSS", size=1, halign="middle", valign="baseline") => @PLACE(168, -152);
//   %wire_103 @TEXT("VSS", size=1, halign="middle", valign="baseline") => @PLACE(224, -152);
//   %wire_102 @TEXT("VSS", size=1, halign="middle", valign="baseline") => @PLACE(280, -152);
//   %wire_101 @TEXT("VSS", size=1, halign="middle", valign="baseline") => @PLACE(336, -152);
//   %wire_100 @TEXT("VSS", size=1, halign="middle", valign="baseline") => @PLACE(392, -152);
//   %wire_99 @TEXT("VSS", size=1, halign="middle", valign="baseline") => @PLACE(0, -200);
//   %wire_98 @TEXT("VSS", size=1, halign="middle", valign="baseline") => @PLACE(56, -200);
//   %wire_97 @TEXT("VSS", size=1, halign="middle", valign="baseline") => @PLACE(112, -200);
//   %wire_96 @TEXT("VSS", size=1, halign="middle", valign="baseline") => @PLACE(168, -200);
//   %wire_95 @TEXT("VSS", size=1, halign="middle", valign="baseline") => @PLACE(224, -200);
//   %wire_94 @TEXT("VSS", size=1, halign="middle", valign="baseline") => @PLACE(280, -200);
//   %wire_93 @TEXT("VSS", size=1, halign="middle", valign="baseline") => @PLACE(336, -200);
//   %wire_92 @TEXT("VSS", size=1, halign="middle", valign="baseline") => @PLACE(392, -200);
//   %wire_91 @TEXT("VSS", size=1, halign="middle", valign="baseline") => @PLACE(0, -248);
//   %wire_90 @TEXT("VSS", size=1, halign="middle", valign="baseline") => @PLACE(56, -248);
//   %wire_89 @TEXT("VSS", size=1, halign="middle", valign="middle") => @PLACE(-60.8, -24);
//   %p132 = (-57.6, -16);
//   %wire_132 = &"VDD" @WIRE(mode="straight") {%port_2:p %p132};
//   %p133 = (56, -228);
//   %wire_133 = &"VDD" @WIRE(mode="straight") {#"XN41":3 %p133};
//   %p134 = (0, -228);
//   %wire_134 = &"VDD" @WIRE(mode="straight") {#"XN40":3 %p134};
//   %p135 = (392, -180);
//   %wire_135 = &"VDD" @WIRE(mode="straight") {#"XN39":3 %p135};
//   %p136 = (336, -180);
//   %wire_136 = &"VDD" @WIRE(mode="straight") {#"XN38":3 %p136};
//   %p137 = (280, -180);
//   %wire_137 = &"VDD" @WIRE(mode="straight") {#"XN37":3 %p137};
//   %p138 = (224, -180);
//   %wire_138 = &"VDD" @WIRE(mode="straight") {#"XN36":3 %p138};
//   %p139 = (168, -180);
//   %wire_139 = &"VDD" @WIRE(mode="straight") {#"XN35":3 %p139};
//   %p140 = (112, -180);
//   %wire_140 = &"VDD" @WIRE(mode="straight") {#"XN34":3 %p140};
//   %p141 = (56, -180);
//   %wire_141 = &"VDD" @WIRE(mode="straight") {#"XN33":3 %p141};
//   %p142 = (0, -180);
//   %wire_142 = &"VDD" @WIRE(mode="straight") {#"XN32":3 %p142};
//   %p143 = (392, -132);
//   %wire_143 = &"VDD" @WIRE(mode="straight") {#"XN31":3 %p143};
//   %p144 = (336, -132);
//   %wire_144 = &"VDD" @WIRE(mode="straight") {#"XN30":3 %p144};
//   %p145 = (280, -132);
//   %wire_145 = &"VDD" @WIRE(mode="straight") {#"XN29":3 %p145};
//   %p146 = (224, -132);
//   %wire_146 = &"VDD" @WIRE(mode="straight") {#"XN28":3 %p146};
//   %p147 = (168, -132);
//   %wire_147 = &"VDD" @WIRE(mode="straight") {#"XN27":3 %p147};
//   %p148 = (112, -132);
//   %wire_148 = &"VDD" @WIRE(mode="straight") {#"XN26":3 %p148};
//   %p149 = (56, -132);
//   %wire_149 = &"VDD" @WIRE(mode="straight") {#"XN25":3 %p149};
//   %p150 = (0, -132);
//   %wire_150 = &"VDD" @WIRE(mode="straight") {#"XN24":3 %p150};
//   %p151 = (392, -84);
//   %wire_151 = &"VDD" @WIRE(mode="straight") {#"XN23":3 %p151};
//   %p152 = (336, -84);
//   %wire_152 = &"VDD" @WIRE(mode="straight") {#"XN22":3 %p152};
//   %p153 = (280, -84);
//   %wire_153 = &"VDD" @WIRE(mode="straight") {#"XN21":3 %p153};
//   %p154 = (224, -84);
//   %wire_154 = &"VDD" @WIRE(mode="straight") {#"XN20":3 %p154};
//   %p155 = (168, -84);
//   %wire_155 = &"VDD" @WIRE(mode="straight") {#"XN19":3 %p155};
//   %p156 = (112, -84);
//   %wire_156 = &"VDD" @WIRE(mode="straight") {#"XN18":3 %p156};
//   %p157 = (56, -84);
//   %wire_157 = &"VDD" @WIRE(mode="straight") {#"XN17":3 %p157};
//   %p158 = (0, -84);
//   %wire_158 = &"VDD" @WIRE(mode="straight") {#"XN16":3 %p158};
//   %p159 = (392, -36);
//   %wire_159 = &"VDD" @WIRE(mode="straight") {#"XN15":3 %p159};
//   %p160 = (336, -36);
//   %wire_160 = &"VDD" @WIRE(mode="straight") {#"XN14":3 %p160};
//   %p161 = (280, -36);
//   %wire_161 = &"VDD" @WIRE(mode="straight") {#"XN13":3 %p161};
//   %p162 = (224, -36);
//   %wire_162 = &"VDD" @WIRE(mode="straight") {#"XN12":3 %p162};
//   %p163 = (168, -36);
//   %wire_163 = &"VDD" @WIRE(mode="straight") {#"XN11":3 %p163};
//   %p164 = (112, -36);
//   %wire_164 = &"VDD" @WIRE(mode="straight") {#"XN10":3 %p164};
//   %p165 = (56, -36);
//   %wire_165 = &"VDD" @WIRE(mode="straight") {#"XN9":3 %p165};
//   %p166 = (0, -36);
//   %wire_166 = &"VDD" @WIRE(mode="straight") {#"XN8":3 %p166};
//   %p167 = (392, 12);
//   %wire_167 = &"VDD" @WIRE(mode="straight") {#"XN7":3 %p167};
//   %p168 = (336, 12);
//   %wire_168 = &"VDD" @WIRE(mode="straight") {#"XN6":3 %p168};
//   %p169 = (280, 12);
//   %wire_169 = &"VDD" @WIRE(mode="straight") {#"XN5":3 %p169};
//   %p170 = (224, 12);
//   %wire_170 = &"VDD" @WIRE(mode="straight") {#"XN4":3 %p170};
//   %p171 = (168, 12);
//   %wire_171 = &"VDD" @WIRE(mode="straight") {#"XN3":3 %p171};
//   %p172 = (112, 12);
//   %wire_172 = &"VDD" @WIRE(mode="straight") {#"XN2":3 %p172};
//   %p173 = (56, 12);
//   %wire_173 = &"VDD" @WIRE(mode="straight") {#"XN1":3 %p173};
//   %p174 = (0, 12);
//   %wire_174 = &"VDD" @WIRE(mode="straight") {#"XN0":3 %p174};
//   %wire_174 @TEXT("VDD", size=1, halign="middle", valign="baseline") => @PLACE(0, 8);
//   %wire_173 @TEXT("VDD", size=1, halign="middle", valign="baseline") => @PLACE(56, 8);
//   %wire_172 @TEXT("VDD", size=1, halign="middle", valign="baseline") => @PLACE(112, 8);
//   %wire_171 @TEXT("VDD", size=1, halign="middle", valign="baseline") => @PLACE(168, 8);
//   %wire_170 @TEXT("VDD", size=1, halign="middle", valign="baseline") => @PLACE(224, 8);
//   %wire_169 @TEXT("VDD", size=1, halign="middle", valign="baseline") => @PLACE(280, 8);
//   %wire_168 @TEXT("VDD", size=1, halign="middle", valign="baseline") => @PLACE(336, 8);
//   %wire_167 @TEXT("VDD", size=1, halign="middle", valign="baseline") => @PLACE(392, 8);
//   %wire_166 @TEXT("VDD", size=1, halign="middle", valign="baseline") => @PLACE(0, -40);
//   %wire_165 @TEXT("VDD", size=1, halign="middle", valign="baseline") => @PLACE(56, -40);
//   %wire_164 @TEXT("VDD", size=1, halign="middle", valign="baseline") => @PLACE(112, -40);
//   %wire_163 @TEXT("VDD", size=1, halign="middle", valign="baseline") => @PLACE(168, -40);
//   %wire_162 @TEXT("VDD", size=1, halign="middle", valign="baseline") => @PLACE(224, -40);
//   %wire_161 @TEXT("VDD", size=1, halign="middle", valign="baseline") => @PLACE(280, -40);
//   %wire_160 @TEXT("VDD", size=1, halign="middle", valign="baseline") => @PLACE(336, -40);
//   %wire_159 @TEXT("VDD", size=1, halign="middle", valign="baseline") => @PLACE(392, -40);
//   %wire_158 @TEXT("VDD", size=1, halign="middle", valign="baseline") => @PLACE(0, -88);
//   %wire_157 @TEXT("VDD", size=1, halign="middle", valign="baseline") => @PLACE(56, -88);
//   %wire_156 @TEXT("VDD", size=1, halign="middle", valign="baseline") => @PLACE(112, -88);
//   %wire_155 @TEXT("VDD", size=1, halign="middle", valign="baseline") => @PLACE(168, -88);
//   %wire_154 @TEXT("VDD", size=1, halign="middle", valign="baseline") => @PLACE(224, -88);
//   %wire_153 @TEXT("VDD", size=1, halign="middle", valign="baseline") => @PLACE(280, -88);
//   %wire_152 @TEXT("VDD", size=1, halign="middle", valign="baseline") => @PLACE(336, -88);
//   %wire_151 @TEXT("VDD", size=1, halign="middle", valign="baseline") => @PLACE(392, -88);
//   %wire_150 @TEXT("VDD", size=1, halign="middle", valign="baseline") => @PLACE(0, -136);
//   %wire_149 @TEXT("VDD", size=1, halign="middle", valign="baseline") => @PLACE(56, -136);
//   %wire_148 @TEXT("VDD", size=1, halign="middle", valign="baseline") => @PLACE(112, -136);
//   %wire_147 @TEXT("VDD", size=1, halign="middle", valign="baseline") => @PLACE(168, -136);
//   %wire_146 @TEXT("VDD", size=1, halign="middle", valign="baseline") => @PLACE(224, -136);
//   %wire_145 @TEXT("VDD", size=1, halign="middle", valign="baseline") => @PLACE(280, -136);
//   %wire_144 @TEXT("VDD", size=1, halign="middle", valign="baseline") => @PLACE(336, -136);
//   %wire_143 @TEXT("VDD", size=1, halign="middle", valign="baseline") => @PLACE(392, -136);
//   %wire_142 @TEXT("VDD", size=1, halign="middle", valign="baseline") => @PLACE(0, -184);
//   %wire_141 @TEXT("VDD", size=1, halign="middle", valign="baseline") => @PLACE(56, -184);
//   %wire_140 @TEXT("VDD", size=1, halign="middle", valign="baseline") => @PLACE(112, -184);
//   %wire_139 @TEXT("VDD", size=1, halign="middle", valign="baseline") => @PLACE(168, -184);
//   %wire_138 @TEXT("VDD", size=1, halign="middle", valign="baseline") => @PLACE(224, -184);
//   %wire_137 @TEXT("VDD", size=1, halign="middle", valign="baseline") => @PLACE(280, -184);
//   %wire_136 @TEXT("VDD", size=1, halign="middle", valign="baseline") => @PLACE(336, -184);
//   %wire_135 @TEXT("VDD", size=1, halign="middle", valign="baseline") => @PLACE(392, -184);
//   %wire_134 @TEXT("VDD", size=1, halign="middle", valign="baseline") => @PLACE(0, -232);
//   %wire_133 @TEXT("VDD", size=1, halign="middle", valign="baseline") => @PLACE(56, -232);
//   %wire_132 @TEXT("VDD", size=1, halign="middle", valign="middle") => @PLACE(-60.8, -16);
//   %p175 = (182, -144);
//   %wire_175 = &"BIN_0" @WIRE(mode="straight") {#"XN27":5 %p175};
//   %wire_175 @TEXT("BIN\_0", size=1, halign="middle", valign="baseline") => @PLACE(178, -144);
//   %p176 = (238, -192);
//   %wire_176 = &"BIN_1" @WIRE(mode="straight") {#"XN36":5 %p176};
//   %wire_176 @TEXT("BIN\_1", size=1, halign="middle", valign="baseline") => @PLACE(234, -192);
//   %p177 = (406, -192);
//   %wire_177 = &"BIN_2" @WIRE(mode="straight") {#"XN39":5 %p177};
//   %wire_177 @TEXT("BIN\_2", size=1, halign="middle", valign="baseline") => @PLACE(402, -192);
//   %p178 = (70, -240);
//   %wire_178 = &"BIN_3" @WIRE(mode="straight") {#"XN41":5 %p178};
//   %wire_178 @TEXT("BIN\_3", size=1, halign="middle", valign="baseline") => @PLACE(66, -240);
//   %p179 = (-57.6, -8);
//   %wire_179 = {&"BIN_0" &"BIN_1" &"BIN_2" &"BIN_3"} @WIRE(mode="straight") {%port_1:1 %p179};
//   %wire_179 @TEXT("BIN<3:0>", size=1, halign="middle", valign="middle") => @PLACE(-60.8, -8);
//   %p180 = (381, 1);
//   %wire_180 = &"D_0" @WIRE(mode="straight") {%p180 #"XN7":1};
//   %wire_180 @TEXT("D\_0", size=1, halign="middle", valign="baseline") => @PLACE(385, 1);
//   %p181 = (213, -143);
//   %wire_181 = &"D_1" @WIRE(mode="straight") {%p181 #"XN28":1};
//   %p182 = (-11, -1);
//   %wire_182 = &"D_1" @WIRE(mode="straight") {%p182 #"XN0":2};
//   %p183 = (-11, 1);
//   %wire_183 = &"D_1" @WIRE(mode="straight") {%p183 #"XN0":1};
//   %wire_183 @TEXT("D\_1", size=1, halign="middle", valign="baseline") => @PLACE(-7, 1);
//   %wire_182 @TEXT("D\_1", size=1, halign="middle", valign="baseline") => @PLACE(-7, -1);
//   %wire_181 @TEXT("D\_1", size=1, halign="middle", valign="baseline") => @PLACE(217, -143);
//   %p184 = (-11, -47);
//   %wire_184 = &"D_2" @WIRE(mode="straight") {%p184 #"XN8":1};
//   %wire_184 @TEXT("D\_2", size=1, halign="middle", valign="baseline") => @PLACE(-7, -47);
//   %p185 = (269, -191);
//   %wire_185 = &"D_3" @WIRE(mode="straight") {%p185 #"XN37":1};
//   %p186 = (45, -1);
//   %wire_186 = &"D_3" @WIRE(mode="straight") {%p186 #"XN1":2};
//   %p187 = (45, 1);
//   %wire_187 = &"D_3" @WIRE(mode="straight") {%p187 #"XN1":1};
//   %wire_187 @TEXT("D\_3", size=1, halign="middle", valign="baseline") => @PLACE(49, 1);
//   %wire_186 @TEXT("D\_3", size=1, halign="middle", valign="baseline") => @PLACE(49, -1);
//   %wire_185 @TEXT("D\_3", size=1, halign="middle", valign="baseline") => @PLACE(273, -191);
//   %p188 = (45, -47);
//   %wire_188 = &"D_4" @WIRE(mode="straight") {%p188 #"XN9":1};
//   %wire_188 @TEXT("D\_4", size=1, halign="middle", valign="baseline") => @PLACE(49, -47);
//   %p189 = (269, -143);
//   %wire_189 = &"D_5" @WIRE(mode="straight") {%p189 #"XN29":1};
//   %p190 = (101, -1);
//   %wire_190 = &"D_5" @WIRE(mode="straight") {%p190 #"XN2":2};
//   %p191 = (101, 1);
//   %wire_191 = &"D_5" @WIRE(mode="straight") {%p191 #"XN2":1};
//   %wire_191 @TEXT("D\_5", size=1, halign="middle", valign="baseline") => @PLACE(105, 1);
//   %wire_190 @TEXT("D\_5", size=1, halign="middle", valign="baseline") => @PLACE(105, -1);
//   %wire_189 @TEXT("D\_5", size=1, halign="middle", valign="baseline") => @PLACE(273, -143);
//   %p192 = (101, -47);
//   %wire_192 = &"D_6" @WIRE(mode="straight") {%p192 #"XN10":1};
//   %wire_192 @TEXT("D\_6", size=1, halign="middle", valign="baseline") => @PLACE(105, -47);
//   %p193 = (-11, -241);
//   %wire_193 = &"D_7" @WIRE(mode="straight") {%p193 #"XN40":2};
//   %p194 = (-11, -239);
//   %wire_194 = &"D_7" @WIRE(mode="straight") {%p194 #"XN40":1};
//   %p195 = (157, -1);
//   %wire_195 = &"D_7" @WIRE(mode="straight") {%p195 #"XN3":2};
//   %p196 = (157, 1);
//   %wire_196 = &"D_7" @WIRE(mode="straight") {%p196 #"XN3":1};
//   %wire_196 @TEXT("D\_7", size=1, halign="middle", valign="baseline") => @PLACE(161, 1);
//   %wire_195 @TEXT("D\_7", size=1, halign="middle", valign="baseline") => @PLACE(161, -1);
//   %wire_194 @TEXT("D\_7", size=1, halign="middle", valign="baseline") => @PLACE(-7, -239);
//   %wire_193 @TEXT("D\_7", size=1, halign="middle", valign="baseline") => @PLACE(-7, -241);
//   %p197 = (157, -47);
//   %wire_197 = &"D_8" @WIRE(mode="straight") {%p197 #"XN11":1};
//   %wire_197 @TEXT("D\_8", size=1, halign="middle", valign="baseline") => @PLACE(161, -47);
//   %p198 = (325, -143);
//   %wire_198 = &"D_9" @WIRE(mode="straight") {%p198 #"XN30":1};
//   %p199 = (213, -1);
//   %wire_199 = &"D_9" @WIRE(mode="straight") {%p199 #"XN4":2};
//   %p200 = (213, 1);
//   %wire_200 = &"D_9" @WIRE(mode="straight") {%p200 #"XN4":1};
//   %wire_200 @TEXT("D\_9", size=1, halign="middle", valign="baseline") => @PLACE(217, 1);
//   %wire_199 @TEXT("D\_9", size=1, halign="middle", valign="baseline") => @PLACE(217, -1);
//   %wire_198 @TEXT("D\_9", size=1, halign="middle", valign="baseline") => @PLACE(329, -143);
//   %p201 = (213, -47);
//   %wire_201 = &"D_10" @WIRE(mode="straight") {%p201 #"XN12":1};
//   %wire_201 @TEXT("D\_10", size=1, halign="middle", valign="baseline") => @PLACE(217, -47);
//   %p202 = (325, -193);
//   %wire_202 = &"D_11" @WIRE(mode="straight") {%p202 #"XN38":2};
//   %p203 = (325, -191);
//   %wire_203 = &"D_11" @WIRE(mode="straight") {%p203 #"XN38":1};
//   %p204 = (269, -1);
//   %wire_204 = &"D_11" @WIRE(mode="straight") {%p204 #"XN5":2};
//   %p205 = (269, 1);
//   %wire_205 = &"D_11" @WIRE(mode="straight") {%p205 #"XN5":1};
//   %wire_205 @TEXT("D\_11", size=1, halign="middle", valign="baseline") => @PLACE(273, 1);
//   %wire_204 @TEXT("D\_11", size=1, halign="middle", valign="baseline") => @PLACE(273, -1);
//   %wire_203 @TEXT("D\_11", size=1, halign="middle", valign="baseline") => @PLACE(329, -191);
//   %wire_202 @TEXT("D\_11", size=1, halign="middle", valign="baseline") => @PLACE(329, -193);
//   %p206 = (269, -47);
//   %wire_206 = &"D_12" @WIRE(mode="straight") {%p206 #"XN13":1};
//   %wire_206 @TEXT("D\_12", size=1, halign="middle", valign="baseline") => @PLACE(273, -47);
//   %p207 = (381, -145);
//   %wire_207 = &"D_13" @WIRE(mode="straight") {%p207 #"XN31":2};
//   %p208 = (381, -143);
//   %wire_208 = &"D_13" @WIRE(mode="straight") {%p208 #"XN31":1};
//   %p209 = (325, -1);
//   %wire_209 = &"D_13" @WIRE(mode="straight") {%p209 #"XN6":2};
//   %p210 = (325, 1);
//   %wire_210 = &"D_13" @WIRE(mode="straight") {%p210 #"XN6":1};
//   %wire_210 @TEXT("D\_13", size=1, halign="middle", valign="baseline") => @PLACE(329, 1);
//   %wire_209 @TEXT("D\_13", size=1, halign="middle", valign="baseline") => @PLACE(329, -1);
//   %wire_208 @TEXT("D\_13", size=1, halign="middle", valign="baseline") => @PLACE(385, -143);
//   %wire_207 @TEXT("D\_13", size=1, halign="middle", valign="baseline") => @PLACE(385, -145);
//   %p211 = (325, -49);
//   %wire_211 = &"D_14" @WIRE(mode="straight") {%p211 #"XN14":2};
//   %p212 = (325, -47);
//   %wire_212 = &"D_14" @WIRE(mode="straight") {%p212 #"XN14":1};
//   %wire_212 @TEXT("D\_14", size=1, halign="middle", valign="baseline") => @PLACE(329, -47);
//   %wire_211 @TEXT("D\_14", size=1, halign="middle", valign="baseline") => @PLACE(329, -49);
//   %p213 = (-57.6, 0);
//   %wire_213 = {&"D_0" &"D_1" &"D_2" &"D_3" &"D_4" &"D_5" &"D_6" &"D_7" &"D_8" &"D_9" &"D_10" &"D_11" &"D_12" &"D_13" &"D_14"} @WIRE(mode="straight") {%port_0:1 %p213};
//   %wire_213 @TEXT("D<14:0>", size=1, halign="middle", valign="middle") => @PLACE(-60.8, 0)
// }
ends L4_stage1_flash4_encoder
