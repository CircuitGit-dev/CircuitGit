// Explicit native hierarchy assembly; no automatic inclusion.
simulator lang=spectre
include "Switch.scs"
