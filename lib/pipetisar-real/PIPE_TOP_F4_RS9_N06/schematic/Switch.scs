// RNL cell 2026_PIPETISAR_RESEARCH/Switch
// @RNL(type="header") {
//   @VERSION("0.3");
//   @USE-PACKAGE(name="rnl-std-spectre", version="0.3", path="rnl-std-spectre.rnl");
//   @USE-PACKAGE(name="eda-symbol", version="0.1", path="eda-symbol.rnl");
//   @USE-PACKAGE(name="eda-style", version="0.1", path="eda-style.rnl")
// }
subckt Switch A B ctrl
parameters Rseries=50
    R0 (B net12) resistor r=Rseries
    W0 (net12 A ctrl 0) relay vt1=499.5m vt2=500.5m ropen=1T \
        rclosed=100.0m
// @RNL(author="rnl-virtuoso") {
//   %block_symbol = @DEFINE-SYMBOL(box=[0, 0, 8, 2]) {
//     @LINE {(2, 0) (6, 2)};
//     @LINE {(4, 2) (4, 1)};
//     @LINE {(6, 0) (8, 0)};
//     @LINE {(0, 0) (2, 0)};
//     ? @TEXT("${name}", size=1, halign="start", valign="middle", key="name") => @PLACE(0, 3);
//     (4, 2) @PIN(terminal="ctrl");
//     (3, 2.4) @TEXT("ctrl", size=1, halign="end", valign="middle", rotate=90);
//     (8, 0) @PIN(terminal="B");
//     (7.4, 1) @TEXT("B", size=1, halign="end", valign="middle");
//     (0, 0) @PIN(terminal="A");
//     (0.6, 1) @TEXT("A", size=1, halign="start", valign="middle")
//   };
//   # @SET-SYMBOL %block_symbol;
//   #"W0" @SET-SYMBOL $VOLTAGE_CONTROLLED_SWITCH;
//   #"W0" @PLACE(1, 2) => @ORIENT("MYR90");
//   #"R0" @SET-SYMBOL $RESISTOR;
//   #"R0" @PLACE(-1, 8) => @ORIENT("R0");
//   %marker_1 = $GROUND @ATTACH &"0" => @PLACE(3, -1) => @ORIENT("R0");
//   %port_0 = $IO_PORT @ATTACH &"B" => @PLACE(-2, 16) => @ORIENT("R0");
//   %port_1 = $IO_PORT @ATTACH &"A" => @PLACE(-2, -9) => @ORIENT("R0");
//   %input_port_symbol = @DEFINE-SYMBOL(box=[-2, -1, 0, 1]) {
//       @LINE(fill="linecolor", linestyle="none") {(-2, -0.9) (-2, 0.9) (-0.9, 0.9) (0, 0) (-0.9, -0.9) (-2, -0.9)};
//       (0, 0) @PIN(terminal=1, direction="right");
//       ? @TEXT("${name}", key="name", halign="middle") => @PLACE(-1, 1.6)
//     };
//   %port_2 = $IO_PORT @ATTACH &"ctrl" => @PLACE(3, 10) => @ORIENT("R270");
//   %port_2 @SET-SYMBOL %input_port_symbol;
//   %port_2 @TEXT("ctrl", key="name");
//   %wire_0 = &"net12" @WIRE(mode="straight") {#"R0":2 #"W0":1};
//   %wire_1 = &"0" @WIRE(mode="straight") {%marker_1:p #"W0":4};
//   %wire_2 = &"ctrl" @WIRE(mode="straight") {#"W0":3 %port_2:p};
//   %p0 = (-1, -9);
//   %wire_3 = &"A" @WIRE(mode="straight") {%p0 #"W0":2};
//   %wire_4 = &"A" @WIRE(mode="straight") {%port_1:p %p0};
//   %p1 = (-1, 16);
//   %wire_5 = &"B" @WIRE(mode="straight") {%port_0:p %p1};
//   %wire_6 = &"B" @WIRE(mode="straight") {#"R0":1 %p1};
//   (2, -14) @TEXT("Switch close for CLK > 0.5V Switch open for CLK < 0.5V", size=1, halign="middle", valign="baseline")
// }
ends Switch
