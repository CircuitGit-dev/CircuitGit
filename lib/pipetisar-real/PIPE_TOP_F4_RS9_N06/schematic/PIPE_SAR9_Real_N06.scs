// RNL cell 2026_PIPETISAR_RESEARCH/PIPE_SAR9_Real_N06
// @RNL(type="header") {
//   @VERSION("0.3");
//   @USE-PACKAGE(name="rnl-std-spectre", version="0.3", path="rnl-std-spectre.rnl");
//   @USE-PACKAGE(name="eda-symbol", version="0.1", path="eda-symbol.rnl");
//   @USE-PACKAGE(name="eda-style", version="0.1", path="eda-style.rnl")
// }
subckt PIPE_SAR9_Real_N06 BUSY DONE KIN_3 KIN_2 KIN_1 KIN_0 KOUT_3 KOUT_2 \
        KOUT_1 KOUT_0 OVF Q_8 Q_7 Q_6 Q_5 Q_4 Q_3 Q_2 Q_1 Q_0 STEP TRACK \
        VCM VDAC VDD VH VIN VIP VREFN VREFP VSS
    XIO (TRACK KIN_3 KIN_2 KIN_1 KIN_0 RAW_9 RAW_8 RAW_7 RAW_6 RAW_5 RAW_4 \
        RAW_3 RAW_2 RAW_1 RAW_0 EOC CLKC VIP VIN CLKA CLKAE CLKB CLKD Q_8 \
        Q_7 Q_6 Q_5 Q_4 Q_3 Q_2 Q_1 Q_0 KOUT_3 KOUT_2 KOUT_1 KOUT_0 DONE \
        BUSY OVF STEP VH VDAC VDD VSS) RS9_IO_N06 tr=1p trackwidth=490p \
        early=20p startgap=20p tbudget=1400p tcapture=50p vfs=2
    XCORE (VDD VSS CLKA CLKAE CLKB CLKC CLKD RAW_9 RAW_8 RAW_7 RAW_6 RAW_5 \
        RAW_4 RAW_3 RAW_2 RAW_1 RAW_0 EOC VDD VSS TOPNB TOPPB VBSTN VBSTP \
        VCM VCM VIP VIN VREFN VREFP) RS9_L3_9bit_SAR_2
// @RNL(author="rnl-virtuoso") {
//   %block_symbol = @DEFINE-SYMBOL(box=[0, -83.2, 72, 4.8]) {
//     @RECTANGLE {(0, -83.2) (72, 4.8)};
//     (36, 10.4) @TEXT("REAL SAR  /  9b", size=4.6, halign="middle", valign="middle");
//     ? @TEXT("${name}", size=3.8, halign="middle", valign="middle", key="name") => @PLACE(36, -88.3);
//     (0, 0) @PIN(terminal="VIP");
//     (2.2, 0) @TEXT("VIP", size=3.8, halign="start", valign="middle");
//     (0, -12.8) @PIN(terminal="VIN");
//     (2.2, -12.8) @TEXT("VIN", size=3.8, halign="start", valign="middle");
//     (0, -25.6) @PIN(terminal="TRACK");
//     (2.2, -25.6) @TEXT("TRACK", size=3.8, halign="start", valign="middle");
//     (0, -33.6) @PIN(terminal=["KIN_3", "KIN_2", "KIN_1", "KIN_0"]);
//     (2.2, -33.6) @TEXT("KIN<3:0>", size=3.8, halign="start", valign="middle");
//     (0, -46.4) @PIN(terminal="VREFP");
//     (2.2, -46.4) @TEXT("VREFP", size=3.8, halign="start", valign="middle");
//     (0, -54.4) @PIN(terminal="VREFN");
//     (2.2, -54.4) @TEXT("VREFN", size=3.8, halign="start", valign="middle");
//     (0, -62.4) @PIN(terminal="VCM");
//     (2.2, -62.4) @TEXT("VCM", size=3.8, halign="start", valign="middle");
//     (0, -70.4) @PIN(terminal="VDD");
//     (2.2, -70.4) @TEXT("VDD", size=3.8, halign="start", valign="middle");
//     (0, -78.4) @PIN(terminal="VSS");
//     (2.2, -78.4) @TEXT("VSS", size=3.8, halign="start", valign="middle");
//     (72, 0) @PIN(terminal=["Q_8", "Q_7", "Q_6", "Q_5", "Q_4", "Q_3", "Q_2", "Q_1", "Q_0"]);
//     (69.8, 0) @TEXT("Q<8:0>", size=3.8, halign="end", valign="middle");
//     (72, -8) @PIN(terminal=["KOUT_3", "KOUT_2", "KOUT_1", "KOUT_0"]);
//     (69.8, -8) @TEXT("KOUT<3:0>", size=3.8, halign="end", valign="middle");
//     (72, -16) @PIN(terminal="DONE");
//     (69.8, -16) @TEXT("DONE", size=3.8, halign="end", valign="middle");
//     (72, -24) @PIN(terminal="OVF");
//     (69.8, -24) @TEXT("OVF", size=3.8, halign="end", valign="middle");
//     (72, -40) @PIN(terminal="BUSY");
//     (69.8, -40) @TEXT("BUSY", size=3.8, halign="end", valign="middle");
//     (72, -48) @PIN(terminal="VH");
//     (69.8, -48) @TEXT("VH", size=3.8, halign="end", valign="middle");
//     (72, -56) @PIN(terminal="VDAC");
//     (69.8, -56) @TEXT("VDAC", size=3.8, halign="end", valign="middle");
//     (72, -64) @PIN(terminal="STEP");
//     (69.8, -64) @TEXT("STEP", size=3.8, halign="end", valign="middle")
//   };
//   # @SET-SYMBOL %block_symbol;
//   #"XCORE" @PLACE(48, 0) => @ORIENT("R0");
//   %symbol_0 = @DEFINE-SYMBOL(box=[0, -131.2, 83.2, 4.8]) {
//     @RECTANGLE {(0, -131.2) (83.2, 4.8)};
//     (41.6, 10.4) @TEXT("CLOCK + DECODE", size=4.6, halign="middle", valign="middle");
//     ? @TEXT("${name}", size=3.8, halign="middle", valign="middle", key="name") => @PLACE(41.6, -136.3);
//     (0, 0) @PIN(terminal=[6, 7, 8, 9, 10, 11, 12, 13, 14, 15]);
//     (2.2, 0) @TEXT("RAW<9:0>", size=3.8, halign="start", valign="middle");
//     (0, -8) @PIN(terminal=16);
//     (2.2, -8) @TEXT("EOC", size=3.8, halign="start", valign="middle");
//     (0, -16) @PIN(terminal=17);
//     (2.2, -16) @TEXT("CLKC", size=3.8, halign="start", valign="middle");
//     (0, -32) @PIN(terminal=20);
//     (2.2, -32) @TEXT("CLKA", size=3.8, halign="start", valign="middle");
//     (0, -40) @PIN(terminal=21);
//     (2.2, -40) @TEXT("CLKAE", size=3.8, halign="start", valign="middle");
//     (0, -48) @PIN(terminal=22);
//     (2.2, -48) @TEXT("CLKB", size=3.8, halign="start", valign="middle");
//     (0, -56) @PIN(terminal=23);
//     (2.2, -56) @TEXT("CLKD", size=3.8, halign="start", valign="middle");
//     (0, -70.4) @PIN(terminal=1);
//     (2.2, -70.4) @TEXT("TRACK", size=3.8, halign="start", valign="middle");
//     (0, -78.4) @PIN(terminal=[2, 3, 4, 5]);
//     (2.2, -78.4) @TEXT("KIN<3:0>", size=3.8, halign="start", valign="middle");
//     (0, -94.4) @PIN(terminal=18);
//     (2.2, -94.4) @TEXT("VIP", size=3.8, halign="start", valign="middle");
//     (0, -102.4) @PIN(terminal=19);
//     (2.2, -102.4) @TEXT("VIN", size=3.8, halign="start", valign="middle");
//     (0, -118.4) @PIN(terminal=43);
//     (2.2, -118.4) @TEXT("VDD", size=3.8, halign="start", valign="middle");
//     (0, -126.4) @PIN(terminal=44);
//     (2.2, -126.4) @TEXT("VSS", size=3.8, halign="start", valign="middle");
//     (83.2, 0) @PIN(terminal=[24, 25, 26, 27, 28, 29, 30, 31, 32]);
//     (81, 0) @TEXT("Q<8:0>", size=3.8, halign="end", valign="middle");
//     (83.2, -8) @PIN(terminal=[33, 34, 35, 36]);
//     (81, -8) @TEXT("KOUT<3:0>", size=3.8, halign="end", valign="middle");
//     (83.2, -16) @PIN(terminal=37);
//     (81, -16) @TEXT("DONE", size=3.8, halign="end", valign="middle");
//     (83.2, -24) @PIN(terminal=39);
//     (81, -24) @TEXT("OVF", size=3.8, halign="end", valign="middle");
//     (83.2, -48) @PIN(terminal=38);
//     (81, -48) @TEXT("BUSY", size=3.8, halign="end", valign="middle");
//     (83.2, -64) @PIN(terminal=41);
//     (81, -64) @TEXT("VH", size=3.8, halign="end", valign="middle");
//     (83.2, -72) @PIN(terminal=42);
//     (81, -72) @TEXT("VDAC", size=3.8, halign="end", valign="middle");
//     (83.2, -80) @PIN(terminal=40);
//     (81, -80) @TEXT("STEP", size=3.8, halign="end", valign="middle")
//   };
//   #"XIO" @SET-SYMBOL %symbol_0;
//   #"XIO" @PLACE(192, 0) => @ORIENT("R0");
//   %marker_2 = (155.2, -86.4);
//   $FIGURE @ATTACH %marker_2 => @SET-SYMBOL $NO_CONNECT_SYMBOL => @ORIENT("R0");
//   %marker_3 = (155.2, -78.4);
//   $FIGURE @ATTACH %marker_3 => @SET-SYMBOL $NO_CONNECT_SYMBOL => @ORIENT("R0");
//   %marker_4 = (155.2, -94.4);
//   $FIGURE @ATTACH %marker_4 => @SET-SYMBOL $NO_CONNECT_SYMBOL => @ORIENT("R0");
//   %marker_5 = (155.2, -70.4);
//   $FIGURE @ATTACH %marker_5 => @SET-SYMBOL $NO_CONNECT_SYMBOL => @ORIENT("R0");
//   %output_port_symbol = @DEFINE-SYMBOL(box=[0, -1, 2, 1]) {
//       @LINE(fill="linecolor", linestyle="none") {(0, -0.9) (0, 0.9) (1.1, 0.9) (2, 0) (1.1, -0.9) (0, -0.9)};
//       (0, 0) @PIN(terminal=1, direction="left");
//       ? @TEXT("${name}", key="name", halign="middle") => @PLACE(1, 1.6)
//     };
//   %port_0 = $IO_PORT @ATTACH &"STEP" => @PLACE(307.2, -80) => @ORIENT("R0");
//   %port_0 @SET-SYMBOL %output_port_symbol;
//   %port_0 @TEXT("STEP", key="name");
//   %port_1 = $IO_PORT @ATTACH &"VDAC" => @PLACE(307.2, -72) => @ORIENT("R0");
//   %port_1 @SET-SYMBOL %output_port_symbol;
//   %port_1 @TEXT("VDAC", key="name");
//   %port_2 = $IO_PORT @ATTACH &"VH" => @PLACE(307.2, -64) => @ORIENT("R0");
//   %port_2 @SET-SYMBOL %output_port_symbol;
//   %port_2 @TEXT("VH", key="name");
//   %port_3 = $IO_PORT @ATTACH &"BUSY" => @PLACE(307.2, -48) => @ORIENT("R0");
//   %port_3 @SET-SYMBOL %output_port_symbol;
//   %port_3 @TEXT("BUSY", key="name");
//   %port_4 = $IO_PORT @ATTACH &"OVF" => @PLACE(307.2, -24) => @ORIENT("R0");
//   %port_4 @SET-SYMBOL %output_port_symbol;
//   %port_4 @TEXT("OVF", key="name");
//   %port_5 = $IO_PORT @ATTACH &"DONE" => @PLACE(307.2, -16) => @ORIENT("R0");
//   %port_5 @SET-SYMBOL %output_port_symbol;
//   %port_5 @TEXT("DONE", key="name");
//   %bus_port_type_6 = @DEFINE(roles=[["p", "net"], ["p1", "net"], ["p2", "net"], ["p3", "net"]]) {};
//   %bus_port_type_6_symbol = @DEFINE-SYMBOL {(0, 0) @PIN(terminal=[1, 2, 3, 4])};
//   {&"KOUT_3" &"KOUT_2" &"KOUT_1" &"KOUT_0"} @REMOVE-FROM $PORT_FILL_SET;
//   %port_6 = %bus_port_type_6 @ATTACH &"KOUT_3" &"KOUT_2" &"KOUT_1" &"KOUT_0" => @PLACE(307.2, -8) => @ORIENT("R0");
//   %port_6 @SET-SYMBOL %bus_port_type_6_symbol;
//   %port_6_marker = $IO_PORT @ATTACH &"KOUT_3" => @PLACE(307.2, -8) => @ORIENT("R0");
//   %port_6_marker @SET-SYMBOL %output_port_symbol;
//   %port_6_marker @TEXT("KOUT<3:0>", key="name");
//   %bus_port_type_7 = @DEFINE(roles=[["p", "net"], ["p1", "net"], ["p2", "net"], ["p3", "net"], ["p4", "net"], ["p5", "net"], ["p6", "net"], ["p7", "net"], ["p8", "net"]]) {};
//   %bus_port_type_7_symbol = @DEFINE-SYMBOL {(0, 0) @PIN(terminal=[1, 2, 3, 4, 5, 6, 7, 8, 9])};
//   {&"Q_8" &"Q_7" &"Q_6" &"Q_5" &"Q_4" &"Q_3" &"Q_2" &"Q_1" &"Q_0"} @REMOVE-FROM $PORT_FILL_SET;
//   %port_7 = %bus_port_type_7 @ATTACH &"Q_8" &"Q_7" &"Q_6" &"Q_5" &"Q_4" &"Q_3" &"Q_2" &"Q_1" &"Q_0" => @PLACE(307.2, 0) => @ORIENT("R0");
//   %port_7 @SET-SYMBOL %bus_port_type_7_symbol;
//   %port_7_marker = $IO_PORT @ATTACH &"Q_8" => @PLACE(307.2, 0) => @ORIENT("R0");
//   %port_7_marker @SET-SYMBOL %output_port_symbol;
//   %port_7_marker @TEXT("Q<8:0>", key="name");
//   %input_port_symbol = @DEFINE-SYMBOL(box=[-2, -1, 0, 1]) {
//       @LINE(fill="linecolor", linestyle="none") {(-2, -0.9) (-2, 0.9) (-0.9, 0.9) (0, 0) (-0.9, -0.9) (-2, -0.9)};
//       (0, 0) @PIN(terminal=1, direction="right");
//       ? @TEXT("${name}", key="name", halign="middle") => @PLACE(-1, 1.6)
//     };
//   %bus_port_type_8 = @DEFINE(roles=[["p", "net"], ["p1", "net"], ["p2", "net"], ["p3", "net"]]) {};
//   %bus_port_type_8_symbol = @DEFINE-SYMBOL {(0, 0) @PIN(terminal=[1, 2, 3, 4])};
//   {&"KIN_3" &"KIN_2" &"KIN_1" &"KIN_0"} @REMOVE-FROM $PORT_FILL_SET;
//   %port_8 = %bus_port_type_8 @ATTACH &"KIN_3" &"KIN_2" &"KIN_1" &"KIN_0" => @PLACE(168, -78.4) => @ORIENT("R0");
//   %port_8 @SET-SYMBOL %bus_port_type_8_symbol;
//   %port_8_marker = $IO_PORT @ATTACH &"KIN_3" => @PLACE(168, -78.4) => @ORIENT("R0");
//   %port_8_marker @SET-SYMBOL %input_port_symbol;
//   %port_8_marker @TEXT("KIN<3:0>", key="name");
//   %port_9 = $IO_PORT @ATTACH &"TRACK" => @PLACE(168, -70.4) => @ORIENT("R0");
//   %port_9 @SET-SYMBOL %input_port_symbol;
//   %port_9 @TEXT("TRACK", key="name");
//   %port_10 = $IO_PORT @ATTACH &"VSS" => @PLACE(16, -86.4) => @ORIENT("R0");
//   %port_10 @SET-SYMBOL %input_port_symbol;
//   %port_10 @TEXT("VSS", key="name");
//   %port_11 = $IO_PORT @ATTACH &"VDD" => @PLACE(16, -70.4) => @ORIENT("R0");
//   %port_11 @SET-SYMBOL %input_port_symbol;
//   %port_11 @TEXT("VDD", key="name");
//   %port_12 = $IO_PORT @ATTACH &"VCM" => @PLACE(16, -62.4) => @ORIENT("R0");
//   %port_12 @SET-SYMBOL %input_port_symbol;
//   %port_12 @TEXT("VCM", key="name");
//   %port_13 = $IO_PORT @ATTACH &"VREFN" => @PLACE(16, -46.4) => @ORIENT("R0");
//   %port_13 @SET-SYMBOL %input_port_symbol;
//   %port_13 @TEXT("VREFN", key="name");
//   %port_14 = $IO_PORT @ATTACH &"VREFP" => @PLACE(16, -38.4) => @ORIENT("R0");
//   %port_14 @SET-SYMBOL %input_port_symbol;
//   %port_14 @TEXT("VREFP", key="name");
//   %port_15 = $IO_PORT @ATTACH &"VIN" => @PLACE(16, -12.8) => @ORIENT("R0");
//   %port_15 @SET-SYMBOL %input_port_symbol;
//   %port_15 @TEXT("VIN", key="name");
//   %port_16 = $IO_PORT @ATTACH &"VIP" => @PLACE(16, 0) => @ORIENT("R0");
//   %port_16 @SET-SYMBOL %input_port_symbol;
//   %port_16 @TEXT("VIP", key="name");
//   %wire_0 = &"VBSTN" @WIRE(mode="straight") {#"XCORE":23 %marker_4};
//   %wire_0 @TEXT("VBSTN", size=3.5, halign="middle", valign="baseline") => @PLACE(144.8, -93.5);
//   %wire_1 = &"VBSTP" @WIRE(mode="straight") {#"XCORE":24 %marker_2};
//   %wire_1 @TEXT("VBSTP", size=3.5, halign="middle", valign="baseline") => @PLACE(144.8, -85.5);
//   %wire_2 = &"TOPNB" @WIRE(mode="straight") {#"XCORE":21 %marker_3};
//   %wire_2 @TEXT("TOPNB", size=3.5, halign="middle", valign="baseline") => @PLACE(144.8, -77.5);
//   %wire_3 = &"TOPPB" @WIRE(mode="straight") {#"XCORE":22 %marker_5};
//   %wire_3 @TEXT("TOPPB", size=3.5, halign="middle", valign="baseline") => @PLACE(144.8, -69.5);
//   %wire_4 = &"EOC" @WIRE(mode="straight") {#"XCORE":18 #"XIO":16};
//   %wire_4 @TEXT("EOC", size=3.5, halign="middle", valign="baseline") => @PLACE(163.2, -7.1);
//   %wire_5 = &"CLKD" @WIRE(mode="straight") {#"XCORE":7 #"XIO":23};
//   %wire_5 @TEXT("CLKD", size=3.5, halign="middle", valign="baseline") => @PLACE(163.2, -55.1);
//   %wire_6 = &"CLKC" @WIRE(mode="straight") {#"XCORE":6 #"XIO":17};
//   %wire_6 @TEXT("CLKC", size=3.5, halign="middle", valign="baseline") => @PLACE(163.2, -15.1);
//   %wire_7 = &"CLKB" @WIRE(mode="straight") {#"XCORE":5 #"XIO":22};
//   %wire_7 @TEXT("CLKB", size=3.5, halign="middle", valign="baseline") => @PLACE(163.2, -47.1);
//   %wire_8 = &"CLKAE" @WIRE(mode="straight") {#"XCORE":4 #"XIO":21};
//   %wire_8 @TEXT("CLKAE", size=3.5, halign="middle", valign="baseline") => @PLACE(163.2, -39.1);
//   %wire_9 = &"CLKA" @WIRE(mode="straight") {#"XCORE":3 #"XIO":20};
//   %wire_9 @TEXT("CLKA", size=3.5, halign="middle", valign="baseline") => @PLACE(163.2, -31.1);
//   %wire_10 = {&"RAW_9" &"RAW_8" &"RAW_7" &"RAW_6" &"RAW_5" &"RAW_4" &"RAW_3" &"RAW_2" &"RAW_1" &"RAW_0"} @WIRE(mode="straight") {#"XCORE":8 #"XIO":6};
//   %wire_10 @TEXT("RAW<9:0>", size=3.5, halign="middle", valign="baseline") => @PLACE(163.2, 0.9);
//   %wire_11 = {&"KOUT_3" &"KOUT_2" &"KOUT_1" &"KOUT_0"} @WIRE(mode="straight") {#"XIO":33 %port_6:1};
//   %wire_12 = {&"Q_8" &"Q_7" &"Q_6" &"Q_5" &"Q_4" &"Q_3" &"Q_2" &"Q_1" &"Q_0"} @WIRE(mode="straight") {#"XIO":24 %port_7:1};
//   %wire_13 = &"DONE" @WIRE(mode="straight") {#"XIO":37 %port_5:p};
//   %wire_14 = &"OVF" @WIRE(mode="straight") {#"XIO":39 %port_4:p};
//   %wire_15 = &"BUSY" @WIRE(mode="straight") {#"XIO":38 %port_3:p};
//   %wire_16 = &"VH" @WIRE(mode="straight") {#"XIO":41 %port_2:p};
//   %wire_17 = &"VDAC" @WIRE(mode="straight") {#"XIO":42 %port_1:p};
//   %wire_18 = &"STEP" @WIRE(mode="straight") {#"XIO":40 %port_0:p};
//   %wire_19 = &"VREFN" @WIRE(mode="straight") {%port_13:p #"XCORE":29};
//   %wire_20 = &"VREFP" @WIRE(mode="straight") {%port_14:p #"XCORE":30};
//   %wire_21 = &"VCM" @WIRE(mode="straight") {%port_12:p #"XCORE":26};
//   %p0 = (37.6, -54.4);
//   %wire_22 = &"VCM" @WIRE(mode="straight") {%p0 #"XCORE":25};
//   %wire_22 @TEXT("VCM", size=3.2, halign="end", valign="middle") => @PLACE(36, -54.4);
//   %wire_23 = &"VIP" @WIRE(mode="straight") {%port_16:p #"XCORE":27};
//   %p1 = (181.6, -94.4);
//   %wire_24 = &"VIP" @WIRE(mode="straight") {%p1 #"XIO":18};
//   %wire_24 @TEXT("VIP", size=3.2, halign="end", valign="middle") => @PLACE(180, -94.4);
//   %wire_25 = &"VIN" @WIRE(mode="straight") {%port_15:p #"XCORE":28};
//   %p2 = (181.6, -102.4);
//   %wire_26 = &"VIN" @WIRE(mode="straight") {%p2 #"XIO":19};
//   %wire_26 @TEXT("VIN", size=3.2, halign="end", valign="middle") => @PLACE(180, -102.4);
//   %wire_27 = &"TRACK" @WIRE(mode="straight") {%port_9:p #"XIO":1};
//   %wire_28 = {&"KIN_3" &"KIN_2" &"KIN_1" &"KIN_0"} @WIRE(mode="straight") {%port_8:1 #"XIO":2};
//   %wire_29 = &"VDD" @WIRE(mode="straight") {%port_11:p #"XCORE":1};
//   %p3 = (37.6, -78.4);
//   %wire_30 = &"VDD" @WIRE(mode="straight") {%p3 #"XCORE":19};
//   %p4 = (181.6, -118.4);
//   %wire_31 = &"VDD" @WIRE(mode="straight") {%p4 #"XIO":43};
//   %wire_31 @TEXT("VDD", size=3.2, halign="end", valign="middle") => @PLACE(180, -118.4);
//   %wire_30 @TEXT("VDD", size=3.2, halign="end", valign="middle") => @PLACE(36, -78.4);
//   %wire_32 = &"VSS" @WIRE(mode="straight") {%port_10:p #"XCORE":2};
//   %p5 = (37.6, -94.4);
//   %wire_33 = &"VSS" @WIRE(mode="straight") {%p5 #"XCORE":20};
//   %p6 = (181.6, -126.4);
//   %wire_34 = &"VSS" @WIRE(mode="straight") {%p6 #"XIO":44};
//   %wire_34 @TEXT("VSS", size=3.2, halign="end", valign="middle") => @PLACE(180, -126.4);
//   %wire_33 @TEXT("VSS", size=3.2, halign="end", valign="middle") => @PLACE(36, -94.4);
//   (309.6, -14.4) @TEXT("DONE", size=3.5, halign="start", valign="baseline");
//   (309.6, -6.4) @TEXT("KOUT<3:0>", size=3.5, halign="start", valign="baseline");
//   (309.6, 1.6) @TEXT("Q<8:0>", size=3.5, halign="start", valign="baseline");
//   (171.2, -76.8) @TEXT("KIN<3:0>", size=3.5, halign="start", valign="baseline");
//   (16, -156.8) @TEXT("TRACK falling edge captures input; DONE marks the decoded Q9 result.", size=4.2, halign="start", valign="baseline");
//   (16, -147.2) @TEXT("Raw D9..D0 weights: 216, 140, 72, 38, 20, 12, 6, 4, 2, 1", size=4.2, halign="start", valign="baseline");
//   (171.2, -68.8) @TEXT("TRACK", size=3.5, halign="start", valign="baseline");
//   (16, -126.4) @TEXT("VBSTP / VBSTN: boosted gate monitors", size=4.2, halign="start", valign="baseline");
//   (16, -116.8) @TEXT("TOPPB / TOPNB: CDAC top plates", size=4.2, halign="start", valign="baseline");
//   (13.6, -84.8) @TEXT("VSS", size=3.5, halign="end", valign="baseline");
//   (13.6, -68.8) @TEXT("VDD", size=3.5, halign="end", valign="baseline");
//   (309.6, -70.4) @TEXT("VDAC", size=3.5, halign="start", valign="baseline");
//   (13.6, -60.8) @TEXT("VCM", size=3.5, halign="end", valign="baseline");
//   (309.6, -62.4) @TEXT("VH", size=3.5, halign="start", valign="baseline");
//   (13.6, -44.8) @TEXT("VREFN", size=3.5, halign="end", valign="baseline");
//   (309.6, -46.4) @TEXT("BUSY", size=3.5, halign="start", valign="baseline");
//   (13.6, -36.8) @TEXT("VREFP", size=3.5, halign="end", valign="baseline");
//   (309.6, -22.4) @TEXT("OVF", size=3.5, halign="start", valign="baseline");
//   (13.6, -11.2) @TEXT("VIN", size=3.5, halign="end", valign="baseline");
//   (13.6, 1.6) @TEXT("VIP", size=3.5, halign="end", valign="baseline");
//   (139.2, 14.4) @TEXT("raw decisions ->", size=3.8, halign="start", valign="baseline");
//   (140.8, -25.6) @TEXT("<- control clocks", size=3.8, halign="start", valign="baseline");
//   (309.6, -78.4) @TEXT("STEP", size=3.5, halign="start", valign="baseline");
//   (16, 33.6) @TEXT("SAR LANE  |  transistor core + interface adapter", size=6.4, halign="start", valign="baseline");
//   (16, 22.4) @TEXT("VIP -> core VINN; VIN -> core VINP  (verified polarity)", size=4, halign="start", valign="baseline")
// }
ends PIPE_SAR9_Real_N06
