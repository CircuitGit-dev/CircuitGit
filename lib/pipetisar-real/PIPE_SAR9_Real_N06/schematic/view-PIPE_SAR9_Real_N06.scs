// Explicit native hierarchy assembly; no automatic inclusion.
simulator lang=spectre
include "RS9_L5_9bit_Bootstrap.scs"
include "RS9_L5_9bit_Comparator_LN.scs"
include "RS9_L6_SR_latch_1.scs"
include "RS9_L6_9bit_REF_Logic.scs"
include "RS9_L5_9bit_SAR_Logic_1.scs"
include "RS9_L8_9bit_CDAC_UNIT.scs"
include "RS9_L7_9bit_CDAC.scs"
include "RS9_L6_9bit_RSW.scs"
include "RS9_L5_9bit_RSW_CDAC.scs"
include "RS9_L3_9bit_SAR_2.scs"
include "PIPE_SAR9_Real_N06.scs"
