// RNL cell 2026_PIPETISAR_RESEARCH/RS9_L6_9bit_RSW
// @RNL(type="header") {
//   @VERSION("0.3");
//   @USE-PACKAGE(name="rnl-std-spectre", version="0.3", path="rnl-std-spectre.rnl");
//   @USE-PACKAGE(name="eda-symbol", version="0.1", path="eda-symbol.rnl");
//   @USE-PACKAGE(name="eda-style", version="0.1", path="eda-style.rnl")
// }
subckt RS9_L6_9bit_RSW BOT_9 BOT_8 BOT_7 BOT_6 BOT_5 BOT_4 BOT_3 BOT_2 \
        BOT_1 BOT_0 DACENB RN_9 RN_8 RN_7 RN_6 RN_5 RN_4 RN_3 RN_2 RN_1 \
        RP_9 RP_8 RP_7 RP_6 RP_5 RP_4 RP_3 RP_2 RP_1 VBST VDD VIN VREFN \
        VREFP VSS
    M27 (BOT_7 RN_7 VREFN VSS) nch_lvt_mac l=30n w=500n multi=4 nf=1 \
        sd=100n ad=3.75e-14 as=3.75e-14 pd=1.15u ps=1.15u nrd=0.662935 \
        nrs=0.662935 sa=75.0n sb=75.0n sa1=75.0n sa2=75.0n sa3=75.0n \
        sa4=75.0n sb1=75.0n sb2=75.0n sb3=75.0n spa=100n spa1=100n \
        spa2=100n spa3=100n sap=91.9776n sapb=114.444n spba=115.715n \
        spba1=117.043n dfm_flag=0 spmt=1.11111e+15 spomt=0 \
        spomt1=1.11111e+60 spmb=1.11111e+15 spomb=0 spomb1=1.11111e+60
    M38 (VIN VBST BOT_6 VSS) nch_lvt_mac l=30n w=500n multi=1 nf=1 sd=100n \
        ad=3.75e-14 as=3.75e-14 pd=1.15u ps=1.15u nrd=0.662935 \
        nrs=0.662935 sa=75.0n sb=75.0n sa1=75.0n sa2=75.0n sa3=75.0n \
        sa4=75.0n sb1=75.0n sb2=75.0n sb3=75.0n spa=100n spa1=100n \
        spa2=100n spa3=100n sap=91.9776n sapb=114.444n spba=115.715n \
        spba1=117.043n dfm_flag=0 spmt=1.11111e+15 spomt=0 \
        spomt1=1.11111e+60 spmb=1.11111e+15 spomb=0 spomb1=1.11111e+60
    M37 (VIN VBST BOT_7 VSS) nch_lvt_mac l=30n w=500n multi=2 nf=1 sd=100n \
        ad=3.75e-14 as=3.75e-14 pd=1.15u ps=1.15u nrd=0.662935 \
        nrs=0.662935 sa=75.0n sb=75.0n sa1=75.0n sa2=75.0n sa3=75.0n \
        sa4=75.0n sb1=75.0n sb2=75.0n sb3=75.0n spa=100n spa1=100n \
        spa2=100n spa3=100n sap=91.9776n sapb=114.444n spba=115.715n \
        spba1=117.043n dfm_flag=0 spmt=1.11111e+15 spomt=0 \
        spomt1=1.11111e+60 spmb=1.11111e+15 spomb=0 spomb1=1.11111e+60
    M36 (VIN VBST BOT_8 VSS) nch_lvt_mac l=30n w=500n multi=4 nf=1 sd=100n \
        ad=3.75e-14 as=3.75e-14 pd=1.15u ps=1.15u nrd=0.662935 \
        nrs=0.662935 sa=75.0n sb=75.0n sa1=75.0n sa2=75.0n sa3=75.0n \
        sa4=75.0n sb1=75.0n sb2=75.0n sb3=75.0n spa=100n spa1=100n \
        spa2=100n spa3=100n sap=91.9776n sapb=114.444n spba=115.715n \
        spba1=117.043n dfm_flag=0 spmt=1.11111e+15 spomt=0 \
        spomt1=1.11111e+60 spmb=1.11111e+15 spomb=0 spomb1=1.11111e+60
    M15 (VIN VBST BOT_0 VSS) nch_lvt_mac l=30n w=250.0n multi=1 nf=1 \
        sd=100n ad=1.875e-14 as=1.875e-14 pd=650.0n ps=650.0n nrd=1.338763 \
        nrs=1.338763 sa=75.0n sb=75.0n sa1=75.0n sa2=75.0n sa3=75.0n \
        sa4=75.0n sb1=75.0n sb2=75.0n sb3=75.0n spa=100n spa1=100n \
        spa2=100n spa3=100n sap=91.9776n sapb=114.444n spba=115.715n \
        spba1=117.043n dfm_flag=0 spmt=1.11111e+15 spomt=0 \
        spomt1=1.11111e+60 spmb=1.11111e+15 spomb=0 spomb1=1.11111e+60
    M127 (VIN VBST BOT_9 VSS) nch_lvt_mac l=30n w=500n multi=6 nf=1 \
        sd=100n ad=3.75e-14 as=3.75e-14 pd=1.15u ps=1.15u nrd=0.662935 \
        nrs=0.662935 sa=75.0n sb=75.0n sa1=75.0n sa2=75.0n sa3=75.0n \
        sa4=75.0n sb1=75.0n sb2=75.0n sb3=75.0n spa=100n spa1=100n \
        spa2=100n spa3=100n sap=91.9776n sapb=114.444n spba=115.715n \
        spba1=117.043n dfm_flag=0 spmt=1.11111e+15 spomt=0 \
        spomt1=1.11111e+60 spmb=1.11111e+15 spomb=0 spomb1=1.11111e+60
    M99 (BOT_9 RN_9 VREFN VSS) nch_lvt_mac l=30n w=500n multi=12 nf=1 \
        sd=100n ad=3.75e-14 as=3.75e-14 pd=1.15u ps=1.15u nrd=0.662935 \
        nrs=0.662935 sa=75.0n sb=75.0n sa1=75.0n sa2=75.0n sa3=75.0n \
        sa4=75.0n sb1=75.0n sb2=75.0n sb3=75.0n spa=100n spa1=100n \
        spa2=100n spa3=100n sap=91.9776n sapb=114.444n spba=115.715n \
        spba1=117.043n dfm_flag=0 spmt=1.11111e+15 spomt=0 \
        spomt1=1.11111e+60 spmb=1.11111e+15 spomb=0 spomb1=1.11111e+60
    M31 (BOT_4 RN_4 VREFN VSS) nch_lvt_mac l=30n w=250.0n multi=1 nf=1 \
        sd=100n ad=1.875e-14 as=1.875e-14 pd=650.0n ps=650.0n nrd=1.338763 \
        nrs=1.338763 sa=75.0n sb=75.0n sa1=75.0n sa2=75.0n sa3=75.0n \
        sa4=75.0n sb1=75.0n sb2=75.0n sb3=75.0n spa=100n spa1=100n \
        spa2=100n spa3=100n sap=91.9776n sapb=114.444n spba=115.715n \
        spba1=117.043n dfm_flag=0 spmt=1.11111e+15 spomt=0 \
        spomt1=1.11111e+60 spmb=1.11111e+15 spomb=0 spomb1=1.11111e+60
    M29 (BOT_5 RN_5 VREFN VSS) nch_lvt_mac l=30n w=500n multi=1 nf=1 \
        sd=100n ad=3.75e-14 as=3.75e-14 pd=1.15u ps=1.15u nrd=0.662935 \
        nrs=0.662935 sa=75.0n sb=75.0n sa1=75.0n sa2=75.0n sa3=75.0n \
        sa4=75.0n sb1=75.0n sb2=75.0n sb3=75.0n spa=100n spa1=100n \
        spa2=100n spa3=100n sap=91.9776n sapb=114.444n spba=115.715n \
        spba1=117.043n dfm_flag=0 spmt=1.11111e+15 spomt=0 \
        spomt1=1.11111e+60 spmb=1.11111e+15 spomb=0 spomb1=1.11111e+60
    M33 (BOT_2 RN_2 VREFN VSS) nch_lvt_mac l=30n w=250.0n multi=1 nf=1 \
        sd=100n ad=1.875e-14 as=1.875e-14 pd=650.0n ps=650.0n nrd=1.338763 \
        nrs=1.338763 sa=75.0n sb=75.0n sa1=75.0n sa2=75.0n sa3=75.0n \
        sa4=75.0n sb1=75.0n sb2=75.0n sb3=75.0n spa=100n spa1=100n \
        spa2=100n spa3=100n sap=91.9776n sapb=114.444n spba=115.715n \
        spba1=117.043n dfm_flag=0 spmt=1.11111e+15 spomt=0 \
        spomt1=1.11111e+60 spmb=1.11111e+15 spomb=0 spomb1=1.11111e+60
    M32 (BOT_3 RN_3 VREFN VSS) nch_lvt_mac l=30n w=250.0n multi=1 nf=1 \
        sd=100n ad=1.875e-14 as=1.875e-14 pd=650.0n ps=650.0n nrd=1.338763 \
        nrs=1.338763 sa=75.0n sb=75.0n sa1=75.0n sa2=75.0n sa3=75.0n \
        sa4=75.0n sb1=75.0n sb2=75.0n sb3=75.0n spa=100n spa1=100n \
        spa2=100n spa3=100n sap=91.9776n sapb=114.444n spba=115.715n \
        spba1=117.043n dfm_flag=0 spmt=1.11111e+15 spomt=0 \
        spomt1=1.11111e+60 spmb=1.11111e+15 spomb=0 spomb1=1.11111e+60
    M40 (VIN VBST BOT_4 VSS) nch_lvt_mac l=30n w=500n multi=1 nf=1 sd=100n \
        ad=3.75e-14 as=3.75e-14 pd=1.15u ps=1.15u nrd=0.662935 \
        nrs=0.662935 sa=75.0n sb=75.0n sa1=75.0n sa2=75.0n sa3=75.0n \
        sa4=75.0n sb1=75.0n sb2=75.0n sb3=75.0n spa=100n spa1=100n \
        spa2=100n spa3=100n sap=91.9776n sapb=114.444n spba=115.715n \
        spba1=117.043n dfm_flag=0 spmt=1.11111e+15 spomt=0 \
        spomt1=1.11111e+60 spmb=1.11111e+15 spomb=0 spomb1=1.11111e+60
    M26 (BOT_8 RN_8 VREFN VSS) nch_lvt_mac l=30n w=500n multi=8 nf=1 \
        sd=100n ad=3.75e-14 as=3.75e-14 pd=1.15u ps=1.15u nrd=0.662935 \
        nrs=0.662935 sa=75.0n sb=75.0n sa1=75.0n sa2=75.0n sa3=75.0n \
        sa4=75.0n sb1=75.0n sb2=75.0n sb3=75.0n spa=100n spa1=100n \
        spa2=100n spa3=100n sap=91.9776n sapb=114.444n spba=115.715n \
        spba1=117.043n dfm_flag=0 spmt=1.11111e+15 spomt=0 \
        spomt1=1.11111e+60 spmb=1.11111e+15 spomb=0 spomb1=1.11111e+60
    M34 (BOT_1 RN_1 VREFN VSS) nch_lvt_mac l=30n w=250.0n multi=1 nf=1 \
        sd=100n ad=1.875e-14 as=1.875e-14 pd=650.0n ps=650.0n nrd=1.338763 \
        nrs=1.338763 sa=75.0n sb=75.0n sa1=75.0n sa2=75.0n sa3=75.0n \
        sa4=75.0n sb1=75.0n sb2=75.0n sb3=75.0n spa=100n spa1=100n \
        spa2=100n spa3=100n sap=91.9776n sapb=114.444n spba=115.715n \
        spba1=117.043n dfm_flag=0 spmt=1.11111e+15 spomt=0 \
        spomt1=1.11111e+60 spmb=1.11111e+15 spomb=0 spomb1=1.11111e+60
    M28 (BOT_6 RN_6 VREFN VSS) nch_lvt_mac l=30n w=500n multi=2 nf=1 \
        sd=100n ad=3.75e-14 as=3.75e-14 pd=1.15u ps=1.15u nrd=0.662935 \
        nrs=0.662935 sa=75.0n sb=75.0n sa1=75.0n sa2=75.0n sa3=75.0n \
        sa4=75.0n sb1=75.0n sb2=75.0n sb3=75.0n spa=100n spa1=100n \
        spa2=100n spa3=100n sap=91.9776n sapb=114.444n spba=115.715n \
        spba1=117.043n dfm_flag=0 spmt=1.11111e+15 spomt=0 \
        spomt1=1.11111e+60 spmb=1.11111e+15 spomb=0 spomb1=1.11111e+60
    M43 (VIN VBST BOT_1 VSS) nch_lvt_mac l=30n w=250.0n multi=1 nf=1 \
        sd=100n ad=1.875e-14 as=1.875e-14 pd=650.0n ps=650.0n nrd=1.338763 \
        nrs=1.338763 sa=75.0n sb=75.0n sa1=75.0n sa2=75.0n sa3=75.0n \
        sa4=75.0n sb1=75.0n sb2=75.0n sb3=75.0n spa=100n spa1=100n \
        spa2=100n spa3=100n sap=91.9776n sapb=114.444n spba=115.715n \
        spba1=117.043n dfm_flag=0 spmt=1.11111e+15 spomt=0 \
        spomt1=1.11111e+60 spmb=1.11111e+15 spomb=0 spomb1=1.11111e+60
    M42 (VIN VBST BOT_2 VSS) nch_lvt_mac l=30n w=250.0n multi=1 nf=1 \
        sd=100n ad=1.875e-14 as=1.875e-14 pd=650.0n ps=650.0n nrd=1.338763 \
        nrs=1.338763 sa=75.0n sb=75.0n sa1=75.0n sa2=75.0n sa3=75.0n \
        sa4=75.0n sb1=75.0n sb2=75.0n sb3=75.0n spa=100n spa1=100n \
        spa2=100n spa3=100n sap=91.9776n sapb=114.444n spba=115.715n \
        spba1=117.043n dfm_flag=0 spmt=1.11111e+15 spomt=0 \
        spomt1=1.11111e+60 spmb=1.11111e+15 spomb=0 spomb1=1.11111e+60
    M41 (VIN VBST BOT_3 VSS) nch_lvt_mac l=30n w=250.0n multi=1 nf=1 \
        sd=100n ad=1.875e-14 as=1.875e-14 pd=650.0n ps=650.0n nrd=1.338763 \
        nrs=1.338763 sa=75.0n sb=75.0n sa1=75.0n sa2=75.0n sa3=75.0n \
        sa4=75.0n sb1=75.0n sb2=75.0n sb3=75.0n spa=100n spa1=100n \
        spa2=100n spa3=100n sap=91.9776n sapb=114.444n spba=115.715n \
        spba1=117.043n dfm_flag=0 spmt=1.11111e+15 spomt=0 \
        spomt1=1.11111e+60 spmb=1.11111e+15 spomb=0 spomb1=1.11111e+60
    M39 (VIN VBST BOT_5 VSS) nch_lvt_mac l=30n w=500n multi=1 nf=1 sd=100n \
        ad=3.75e-14 as=3.75e-14 pd=1.15u ps=1.15u nrd=0.662935 \
        nrs=0.662935 sa=75.0n sb=75.0n sa1=75.0n sa2=75.0n sa3=75.0n \
        sa4=75.0n sb1=75.0n sb2=75.0n sb3=75.0n spa=100n spa1=100n \
        spa2=100n spa3=100n sap=91.9776n sapb=114.444n spba=115.715n \
        spba1=117.043n dfm_flag=0 spmt=1.11111e+15 spomt=0 \
        spomt1=1.11111e+60 spmb=1.11111e+15 spomb=0 spomb1=1.11111e+60
    M5 (BOT_7 RP_7 VREFP VDD) pch_lvt_mac l=30n w=500n multi=4 nf=1 \
        sd=100n ad=3.75e-14 as=3.75e-14 pd=1.15u ps=1.15u nrd=0.383209 \
        nrs=0.383209 sa=75.0n sb=75.0n sa1=75.0n sa2=75.0n sa3=75.0n \
        sa4=75.0n sb1=75.0n sb2=75.0n sb3=75.0n spa=100n spa1=100n \
        spa2=100n spa3=100n sap=91.9776n sapb=114.444n spba=115.715n \
        spba1=117.043n dfm_flag=0 spmt=1.11111e+15 spomt=0 \
        spomt1=1.11111e+60 spmb=1.11111e+15 spomb=0 spomb1=1.11111e+60
    M0 (BOT_0 DACENB VREFP VDD) pch_lvt_mac l=30n w=250.0n multi=1 nf=1 \
        sd=100n ad=1.875e-14 as=1.875e-14 pd=650.0n ps=650.0n nrd=0.777777 \
        nrs=0.777777 sa=75.0n sb=75.0n sa1=75.0n sa2=75.0n sa3=75.0n \
        sa4=75.0n sb1=75.0n sb2=75.0n sb3=75.0n spa=100n spa1=100n \
        spa2=100n spa3=100n sap=91.9776n sapb=114.444n spba=115.715n \
        spba1=117.043n dfm_flag=0 spmt=1.11111e+15 spomt=0 \
        spomt1=1.11111e+60 spmb=1.11111e+15 spomb=0 spomb1=1.11111e+60
    M105 (BOT_9 RP_9 VREFP VDD) pch_lvt_mac l=30n w=500n multi=12 nf=1 \
        sd=100n ad=3.75e-14 as=3.75e-14 pd=1.15u ps=1.15u nrd=0.383209 \
        nrs=0.383209 sa=75.0n sb=75.0n sa1=75.0n sa2=75.0n sa3=75.0n \
        sa4=75.0n sb1=75.0n sb2=75.0n sb3=75.0n spa=100n spa1=100n \
        spa2=100n spa3=100n sap=91.9776n sapb=114.444n spba=115.715n \
        spba1=117.043n dfm_flag=0 spmt=1.11111e+15 spomt=0 \
        spomt1=1.11111e+60 spmb=1.11111e+15 spomb=0 spomb1=1.11111e+60
    M7 (BOT_5 RP_5 VREFP VDD) pch_lvt_mac l=30n w=500n multi=1 nf=1 \
        sd=100n ad=3.75e-14 as=3.75e-14 pd=1.15u ps=1.15u nrd=0.383209 \
        nrs=0.383209 sa=75.0n sb=75.0n sa1=75.0n sa2=75.0n sa3=75.0n \
        sa4=75.0n sb1=75.0n sb2=75.0n sb3=75.0n spa=100n spa1=100n \
        spa2=100n spa3=100n sap=91.9776n sapb=114.444n spba=115.715n \
        spba1=117.043n dfm_flag=0 spmt=1.11111e+15 spomt=0 \
        spomt1=1.11111e+60 spmb=1.11111e+15 spomb=0 spomb1=1.11111e+60
    M10 (BOT_3 RP_3 VREFP VDD) pch_lvt_mac l=30n w=250.0n multi=1 nf=1 \
        sd=100n ad=1.875e-14 as=1.875e-14 pd=650.0n ps=650.0n nrd=0.777777 \
        nrs=0.777777 sa=75.0n sb=75.0n sa1=75.0n sa2=75.0n sa3=75.0n \
        sa4=75.0n sb1=75.0n sb2=75.0n sb3=75.0n spa=100n spa1=100n \
        spa2=100n spa3=100n sap=91.9776n sapb=114.444n spba=115.715n \
        spba1=117.043n dfm_flag=0 spmt=1.11111e+15 spomt=0 \
        spomt1=1.11111e+60 spmb=1.11111e+15 spomb=0 spomb1=1.11111e+60
    M6 (BOT_6 RP_6 VREFP VDD) pch_lvt_mac l=30n w=500n multi=2 nf=1 \
        sd=100n ad=3.75e-14 as=3.75e-14 pd=1.15u ps=1.15u nrd=0.383209 \
        nrs=0.383209 sa=75.0n sb=75.0n sa1=75.0n sa2=75.0n sa3=75.0n \
        sa4=75.0n sb1=75.0n sb2=75.0n sb3=75.0n spa=100n spa1=100n \
        spa2=100n spa3=100n sap=91.9776n sapb=114.444n spba=115.715n \
        spba1=117.043n dfm_flag=0 spmt=1.11111e+15 spomt=0 \
        spomt1=1.11111e+60 spmb=1.11111e+15 spomb=0 spomb1=1.11111e+60
    M12 (BOT_1 RP_1 VREFP VDD) pch_lvt_mac l=30n w=250.0n multi=1 nf=1 \
        sd=100n ad=1.875e-14 as=1.875e-14 pd=650.0n ps=650.0n nrd=0.777777 \
        nrs=0.777777 sa=75.0n sb=75.0n sa1=75.0n sa2=75.0n sa3=75.0n \
        sa4=75.0n sb1=75.0n sb2=75.0n sb3=75.0n spa=100n spa1=100n \
        spa2=100n spa3=100n sap=91.9776n sapb=114.444n spba=115.715n \
        spba1=117.043n dfm_flag=0 spmt=1.11111e+15 spomt=0 \
        spomt1=1.11111e+60 spmb=1.11111e+15 spomb=0 spomb1=1.11111e+60
    M4 (BOT_8 RP_8 VREFP VDD) pch_lvt_mac l=30n w=500n multi=8 nf=1 \
        sd=100n ad=3.75e-14 as=3.75e-14 pd=1.15u ps=1.15u nrd=0.383209 \
        nrs=0.383209 sa=75.0n sb=75.0n sa1=75.0n sa2=75.0n sa3=75.0n \
        sa4=75.0n sb1=75.0n sb2=75.0n sb3=75.0n spa=100n spa1=100n \
        spa2=100n spa3=100n sap=91.9776n sapb=114.444n spba=115.715n \
        spba1=117.043n dfm_flag=0 spmt=1.11111e+15 spomt=0 \
        spomt1=1.11111e+60 spmb=1.11111e+15 spomb=0 spomb1=1.11111e+60
    M9 (BOT_2 RP_2 VREFP VDD) pch_lvt_mac l=30n w=250.0n multi=1 nf=1 \
        sd=100n ad=1.875e-14 as=1.875e-14 pd=650.0n ps=650.0n nrd=0.777777 \
        nrs=0.777777 sa=75.0n sb=75.0n sa1=75.0n sa2=75.0n sa3=75.0n \
        sa4=75.0n sb1=75.0n sb2=75.0n sb3=75.0n spa=100n spa1=100n \
        spa2=100n spa3=100n sap=91.9776n sapb=114.444n spba=115.715n \
        spba1=117.043n dfm_flag=0 spmt=1.11111e+15 spomt=0 \
        spomt1=1.11111e+60 spmb=1.11111e+15 spomb=0 spomb1=1.11111e+60
    M8 (BOT_4 RP_4 VREFP VDD) pch_lvt_mac l=30n w=250.0n multi=1 nf=1 \
        sd=100n ad=1.875e-14 as=1.875e-14 pd=650.0n ps=650.0n nrd=0.777777 \
        nrs=0.777777 sa=75.0n sb=75.0n sa1=75.0n sa2=75.0n sa3=75.0n \
        sa4=75.0n sb1=75.0n sb2=75.0n sb3=75.0n spa=100n spa1=100n \
        spa2=100n spa3=100n sap=91.9776n sapb=114.444n spba=115.715n \
        spba1=117.043n dfm_flag=0 spmt=1.11111e+15 spomt=0 \
        spomt1=1.11111e+60 spmb=1.11111e+15 spomb=0 spomb1=1.11111e+60
// @RNL(author="rnl-virtuoso") {
//   %block_symbol = @DEFINE-SYMBOL(box=[0, -18, 36, 11]) {
//     @LINE {(0, -6) (4, -6)};
//     @LINE {(0, -4) (4, -4)};
//     @LINE {(0, -2) (4, -2)};
//     @LINE {(0, 0) (4, 0)};
//     @LINE {(36, 0) (32, 0)};
//     @LINE {(16, 11) (16, 7)};
//     @LINE {(18, 11) (18, 7)};
//     @LINE {(20, 11) (20, 7)};
//     @LINE {(16, -18) (16, -14)};
//     @LINE {(18, -18) (18, -14)};
//     @RECTANGLE {(4, -14) (32, 7)};
//     ? @TEXT("${name}", size=1, halign="start", valign="middle", key="name") => @PLACE(32, 7);
//     ? @TEXT("${model}", size=1, halign="middle", valign="middle", key="model") => @PLACE(18, -3.5);
//     (0, -6) @PIN(terminal="VIN");
//     (4.6, -6) @TEXT("VIN", size=1, halign="start", valign="middle");
//     (0, -4) @PIN(terminal=["RP_9", "RP_8", "RP_7", "RP_6", "RP_5", "RP_4", "RP_3", "RP_2", "RP_1"]);
//     (4.6, -4) @TEXT("RP<9:1>", size=1, halign="start", valign="middle");
//     (36, 0) @PIN(terminal=["BOT_9", "BOT_8", "BOT_7", "BOT_6", "BOT_5", "BOT_4", "BOT_3", "BOT_2", "BOT_1", "BOT_0"]);
//     (31.4, 0) @TEXT("BOT<9:0>", size=1, halign="end", valign="middle");
//     (0, 0) @PIN(terminal="DACENB");
//     (4.6, 0) @TEXT("DACENB", size=1, halign="start", valign="middle");
//     (0, -2) @PIN(terminal=["RN_9", "RN_8", "RN_7", "RN_6", "RN_5", "RN_4", "RN_3", "RN_2", "RN_1"]);
//     (4.6, -2) @TEXT("RN<9:1>", size=1, halign="start", valign="middle");
//     (16, 11) @PIN(terminal="VDD");
//     (16, 6.4) @TEXT("VDD", size=1, halign="end", valign="middle", rotate=90);
//     (18, 11) @PIN(terminal="VREFP");
//     (18, 6.4) @TEXT("VREFP", size=1, halign="end", valign="middle", rotate=90);
//     (20, 11) @PIN(terminal="VBST");
//     (20, 6.4) @TEXT("VBST", size=1, halign="end", valign="middle", rotate=90);
//     (16, -18) @PIN(terminal="VSS");
//     (16, -13.4) @TEXT("VSS", size=1, halign="start", valign="middle", rotate=90);
//     (18, -18) @PIN(terminal="VREFN");
//     (18, -13.4) @TEXT("VREFN", size=1, halign="start", valign="middle", rotate=90)
//   };
//   # @SET-SYMBOL %block_symbol;
//   %symbol_0 = @DEFINE-SYMBOL(box=[-0.1, -2.8, 3.8, 2.8]) {
//     @LINE {(2, 1.5) (4, 1.5) (4, 3)};
//     @LINE {(2, -1.5) (2, 1.5)};
//     @LINE {(3, -1) (4, -1.5) (3, -2)};
//     @LINE {(0, 0) (1.5, 0)};
//     @LINE {(1.5, 1.5) (1.5, -1.5)};
//     @LINE {(2, -1.5) (4, -1.5) (4, -3)};
//     ? @TEXT("${name}", size=0.8, halign="start", valign="baseline", key="name") => @PLACE(5, 3.5);
//     ? @TEXT("${model}", size=0.8, halign="end", valign="baseline", key="model") => @PLACE(3.2, 3.2);
//     (4, -1) @PIN(terminal=4);
//     (4, -3) @PIN(terminal=3);
//     (4, 3) @PIN(terminal=1);
//     (0, 0) @PIN(terminal=2)
//   };
//   #"M37" @SET-SYMBOL %symbol_0;
//   #"M37" @PLACE(40, 27) => @ORIENT("MYR90");
//   %symbol_1 = @DEFINE-SYMBOL(box=[-0.1, -2.8, 3.8, 2.8]) {
//     @LINE {(0, 0) (0.7, 0)};
//     @LINE {(1.5, 1.5) (1.5, -1.5)};
//     @LINE {(2, -1.5) (4, -1.5) (4, -3)};
//     @LINE {(2, 1.5) (4, 1.5) (4, 3)};
//     (1.1, 0) @CIRCLE(radius=0.4);
//     @LINE {(3.7, 2) (2.7, 1.5) (3.7, 1)};
//     @LINE {(2, -1.5) (2, 1.5)};
//     ? @TEXT("${name}", size=0.8, halign="start", valign="baseline", key="name") => @PLACE(4.9, 3.4);
//     ? @TEXT("${model}", size=0.8, halign="end", valign="baseline", key="model") => @PLACE(3.3, 3.2);
//     (4, 3) @PIN(terminal=3);
//     (4, 1) @PIN(terminal=4);
//     (0, 0) @PIN(terminal=2);
//     (4, -3) @PIN(terminal=1)
//   };
//   #"M10" @SET-SYMBOL %symbol_1;
//   #"M10" @PLACE(-43, 33) => @ORIENT("R0");
//   #"M43" @SET-SYMBOL %symbol_0;
//   #"M43" @PLACE(-90, 27) => @ORIENT("MYR90");
//   #"M33" @SET-SYMBOL %symbol_0;
//   #"M33" @PLACE(-64, 15) => @ORIENT("R0");
//   #"M0" @SET-SYMBOL %symbol_1;
//   #"M0" @PLACE(-108, 32) => @ORIENT("R0");
//   #"M28" @SET-SYMBOL %symbol_0;
//   #"M28" @PLACE(23, 15) => @ORIENT("R0");
//   #"M31" @SET-SYMBOL %symbol_0;
//   #"M31" @PLACE(-22, 15) => @ORIENT("R0");
//   #"M9" @SET-SYMBOL %symbol_1;
//   #"M9" @PLACE(-64, 33) => @ORIENT("R0");
//   #"M4" @SET-SYMBOL %symbol_1;
//   #"M4" @PLACE(68, 33) => @ORIENT("R0");
//   #"M36" @SET-SYMBOL %symbol_0;
//   #"M36" @PLACE(63, 27) => @ORIENT("MYR90");
//   #"M34" @SET-SYMBOL %symbol_0;
//   #"M34" @PLACE(-85, 15) => @ORIENT("R0");
//   #"M41" @SET-SYMBOL %symbol_0;
//   #"M41" @PLACE(-48, 27) => @ORIENT("MYR90");
//   #"M39" @SET-SYMBOL %symbol_0;
//   #"M39" @PLACE(-4, 27) => @ORIENT("MYR90");
//   #"M7" @SET-SYMBOL %symbol_1;
//   #"M7" @PLACE(1, 33) => @ORIENT("R0");
//   #"M26" @SET-SYMBOL %symbol_0;
//   #"M26" @PLACE(68, 15) => @ORIENT("R0");
//   #"M42" @SET-SYMBOL %symbol_0;
//   #"M42" @PLACE(-69, 27) => @ORIENT("MYR90");
//   #"M8" @SET-SYMBOL %symbol_1;
//   #"M8" @PLACE(-22, 33) => @ORIENT("R0");
//   #"M99" @SET-SYMBOL %symbol_0;
//   #"M99" @PLACE(91, 15) => @ORIENT("R0");
//   #"M12" @SET-SYMBOL %symbol_1;
//   #"M12" @PLACE(-85, 33) => @ORIENT("R0");
//   #"M6" @SET-SYMBOL %symbol_1;
//   #"M6" @PLACE(23, 33) => @ORIENT("R0");
//   #"M5" @SET-SYMBOL %symbol_1;
//   #"M5" @PLACE(45, 33) => @ORIENT("R0");
//   #"M29" @SET-SYMBOL %symbol_0;
//   #"M29" @PLACE(1, 15) => @ORIENT("R0");
//   #"M127" @SET-SYMBOL %symbol_0;
//   #"M127" @PLACE(86, 27) => @ORIENT("MYR90");
//   #"M40" @SET-SYMBOL %symbol_0;
//   #"M40" @PLACE(-27, 27) => @ORIENT("MYR90");
//   #"M38" @SET-SYMBOL %symbol_0;
//   #"M38" @PLACE(18, 27) => @ORIENT("MYR90");
//   #"M15" @SET-SYMBOL %symbol_0;
//   #"M15" @PLACE(-114, 19) => @ORIENT("R90");
//   #"M32" @SET-SYMBOL %symbol_0;
//   #"M32" @PLACE(-43, 15) => @ORIENT("R0");
//   #"M27" @SET-SYMBOL %symbol_0;
//   #"M27" @PLACE(45, 15) => @ORIENT("R0");
//   #"M105" @SET-SYMBOL %symbol_1;
//   #"M105" @PLACE(91, 33) => @ORIENT("R0");
//   %port_0 = $IO_PORT @ATTACH &"VSS" => @PLACE(-130, 20) => @ORIENT("R0");
//   %input_port_symbol = @DEFINE-SYMBOL(box=[-2, -1, 0, 1]) {
//       @LINE(fill="linecolor", linestyle="none") {(-2, -0.9) (-2, 0.9) (-0.9, 0.9) (0, 0) (-0.9, -0.9) (-2, -0.9)};
//       (0, 0) @PIN(terminal=1, direction="right");
//       ? @TEXT("${name}", key="name", halign="middle") => @PLACE(-1, 1.6)
//     };
//   %port_1 = $IO_PORT @ATTACH &"VREFP" => @PLACE(-129, 29) => @ORIENT("R0");
//   %port_1 @SET-SYMBOL %input_port_symbol;
//   %port_1 @TEXT("VREFP", key="name");
//   %bus_port_type_2 = @DEFINE(roles=[["p", "net"], ["p1", "net"], ["p2", "net"], ["p3", "net"], ["p4", "net"], ["p5", "net"], ["p6", "net"], ["p7", "net"], ["p8", "net"]]) {};
//   %bus_port_type_2_symbol = @DEFINE-SYMBOL {(0, 0) @PIN(terminal=[1, 2, 3, 4, 5, 6, 7, 8, 9])};
//   {&"RP_9" &"RP_8" &"RP_7" &"RP_6" &"RP_5" &"RP_4" &"RP_3" &"RP_2" &"RP_1"} @REMOVE-FROM $PORT_FILL_SET;
//   %port_2 = %bus_port_type_2 @ATTACH &"RP_9" &"RP_8" &"RP_7" &"RP_6" &"RP_5" &"RP_4" &"RP_3" &"RP_2" &"RP_1" => @PLACE(-129, 35) => @ORIENT("R0");
//   %port_2 @SET-SYMBOL %bus_port_type_2_symbol;
//   %port_2_marker = $IO_PORT @ATTACH &"RP_9" => @PLACE(-129, 35) => @ORIENT("R0");
//   %port_2_marker @SET-SYMBOL %input_port_symbol;
//   %port_2_marker @TEXT("RP<9:1>", key="name");
//   %bus_port_type_3 = @DEFINE(roles=[["p", "net"], ["p1", "net"], ["p2", "net"], ["p3", "net"], ["p4", "net"], ["p5", "net"], ["p6", "net"], ["p7", "net"], ["p8", "net"]]) {};
//   %bus_port_type_3_symbol = @DEFINE-SYMBOL {(0, 0) @PIN(terminal=[1, 2, 3, 4, 5, 6, 7, 8, 9])};
//   {&"RN_9" &"RN_8" &"RN_7" &"RN_6" &"RN_5" &"RN_4" &"RN_3" &"RN_2" &"RN_1"} @REMOVE-FROM $PORT_FILL_SET;
//   %port_3 = %bus_port_type_3 @ATTACH &"RN_9" &"RN_8" &"RN_7" &"RN_6" &"RN_5" &"RN_4" &"RN_3" &"RN_2" &"RN_1" => @PLACE(-129, 38) => @ORIENT("R0");
//   %port_3 @SET-SYMBOL %bus_port_type_3_symbol;
//   %port_3_marker = $IO_PORT @ATTACH &"RN_9" => @PLACE(-129, 38) => @ORIENT("R0");
//   %port_3_marker @SET-SYMBOL %input_port_symbol;
//   %port_3_marker @TEXT("RN<9:1>", key="name");
//   %port_4 = $IO_PORT @ATTACH &"VDD" => @PLACE(-130, 23) => @ORIENT("R0");
//   %bus_port_type_5 = @DEFINE(roles=[["p", "net"], ["p1", "net"], ["p2", "net"], ["p3", "net"], ["p4", "net"], ["p5", "net"], ["p6", "net"], ["p7", "net"], ["p8", "net"], ["p9", "net"]]) {};
//   %bus_port_type_5_symbol = @DEFINE-SYMBOL {(0, 0) @PIN(terminal=[1, 2, 3, 4, 5, 6, 7, 8, 9, 10])};
//   {&"BOT_9" &"BOT_8" &"BOT_7" &"BOT_6" &"BOT_5" &"BOT_4" &"BOT_3" &"BOT_2" &"BOT_1" &"BOT_0"} @REMOVE-FROM $PORT_FILL_SET;
//   %port_5 = %bus_port_type_5 @ATTACH &"BOT_9" &"BOT_8" &"BOT_7" &"BOT_6" &"BOT_5" &"BOT_4" &"BOT_3" &"BOT_2" &"BOT_1" &"BOT_0" => @PLACE(-130, 17) => @ORIENT("R0");
//   %port_5 @SET-SYMBOL %bus_port_type_5_symbol;
//   %port_5_marker = $IO_PORT @ATTACH &"BOT_9" => @PLACE(-130, 17) => @ORIENT("R0");
//   %port_5_marker @TEXT("BOT<9:0>", key="name");
//   %port_6 = $IO_PORT @ATTACH &"DACENB" => @PLACE(-129, 32) => @ORIENT("R0");
//   %port_6 @SET-SYMBOL %input_port_symbol;
//   %port_6 @TEXT("DACENB", key="name");
//   %port_7 = $IO_PORT @ATTACH &"VBST" => @PLACE(-129, 11) => @ORIENT("R0");
//   %port_7 @SET-SYMBOL %input_port_symbol;
//   %port_7 @TEXT("VBST", key="name");
//   %port_8 = $IO_PORT @ATTACH &"VIN" => @PLACE(-129, 14) => @ORIENT("R0");
//   %port_8 @SET-SYMBOL %input_port_symbol;
//   %port_8 @TEXT("VIN", key="name");
//   %port_9 = $IO_PORT @ATTACH &"VREFN" => @PLACE(-129, 26) => @ORIENT("R0");
//   %port_9 @SET-SYMBOL %input_port_symbol;
//   %port_9 @TEXT("VREFN", key="name");
//   %p0 = (-47, 15);
//   %wire_0 = &"RN_3" @WIRE(mode="straight") {%p0 #"M32":2};
//   %wire_0 @TEXT("RN\_3", size=1, halign="middle", valign="baseline") => @PLACE(-45, 15.7);
//   %p1 = (-68, 15);
//   %wire_1 = &"RN_2" @WIRE(mode="straight") {%p1 #"M33":2};
//   %wire_1 @TEXT("RN\_2", size=1, halign="middle", valign="baseline") => @PLACE(-66, 15.7);
//   %p2 = (-89, 15);
//   %wire_2 = &"RN_1" @WIRE(mode="straight") {%p2 #"M34":2};
//   %wire_2 @TEXT("RN\_1", size=1, halign="middle", valign="baseline") => @PLACE(-87, 15.7);
//   %p3 = (-47, 33);
//   %wire_3 = &"RP_3" @WIRE(mode="straight") {%p3 #"M10":2};
//   %wire_3 @TEXT("RP\_3", size=1, halign="middle", valign="baseline") => @PLACE(-45, 33.7);
//   %p4 = (-68, 33);
//   %wire_4 = &"RP_2" @WIRE(mode="straight") {%p4 #"M9":2};
//   %wire_4 @TEXT("RP\_2", size=1, halign="middle", valign="baseline") => @PLACE(-66, 33.7);
//   %p5 = (-89, 33);
//   %wire_5 = &"RP_1" @WIRE(mode="straight") {%p5 #"M12":2};
//   %wire_5 @TEXT("RP\_1", size=1, halign="middle", valign="baseline") => @PLACE(-87, 33.7);
//   %p6 = (-18, 41);
//   %wire_6 = &"VREFP" @WIRE(mode="straight") {#"M8":3 %p6};
//   %p7 = (5, 41);
//   %wire_7 = &"VREFP" @WIRE(mode="straight") {#"M7":3 %p7};
//   %p8 = (27, 41);
//   %wire_8 = &"VREFP" @WIRE(mode="straight") {#"M6":3 %p8};
//   %p9 = (49, 41);
//   %wire_9 = &"VREFP" @WIRE(mode="straight") {#"M5":3 %p9};
//   %p10 = (72, 41);
//   %wire_10 = &"VREFP" @WIRE(mode="straight") {#"M4":3 %p10};
//   %p11 = (95, 41);
//   %wire_11 = &"VREFP" @WIRE(mode="straight") {#"M105":3 %p11};
//   %p12 = (-39, 41);
//   %wire_12 = &"VREFP" @WIRE(mode="straight") {#"M10":3 %p12};
//   %p13 = (-81, 41);
//   %wire_13 = &"VREFP" @WIRE(mode="straight") {#"M12":3 %p13};
//   %p14 = (-60, 41);
//   %wire_14 = &"VREFP" @WIRE(mode="straight") {#"M9":3 %p14};
//   %p15 = (-104, 40);
//   %wire_15 = &"VREFP" @WIRE(mode="straight") {#"M0":3 %p15};
//   %wire_15 @TEXT("VREFP", size=1, halign="middle", valign="baseline", rotate=90) => @PLACE(-104.7, 38);
//   %wire_14 @TEXT("VREFP", size=1, halign="middle", valign="baseline", rotate=90) => @PLACE(-60.7, 39);
//   %wire_13 @TEXT("VREFP", size=1, halign="middle", valign="baseline", rotate=90) => @PLACE(-81.7, 39);
//   %wire_11 @TEXT("VREFP", size=1, halign="middle", valign="baseline", rotate=90) => @PLACE(94.3, 39);
//   %wire_12 @TEXT("VREFP", size=1, halign="middle", valign="baseline", rotate=90) => @PLACE(-39.7, 39);
//   %wire_10 @TEXT("VREFP", size=1, halign="middle", valign="baseline", rotate=90) => @PLACE(71.3, 39);
//   %wire_9 @TEXT("VREFP", size=1, halign="middle", valign="baseline", rotate=90) => @PLACE(48.3, 39);
//   %wire_8 @TEXT("VREFP", size=1, halign="middle", valign="baseline", rotate=90) => @PLACE(26.3, 39);
//   %wire_7 @TEXT("VREFP", size=1, halign="middle", valign="baseline", rotate=90) => @PLACE(4.3, 39);
//   %wire_6 @TEXT("VREFP", size=1, halign="middle", valign="baseline", rotate=90) => @PLACE(-18.7, 39);
//   %p16 = (-97, 23);
//   %wire_16 = &"VIN" @WIRE(mode="straight") {%p16 #"M43":1};
//   %p17 = (-76, 23);
//   %wire_17 = &"VIN" @WIRE(mode="straight") {%p17 #"M42":1};
//   %p18 = (-55, 23);
//   %wire_18 = &"VIN" @WIRE(mode="straight") {%p18 #"M41":1};
//   %p19 = (-11, 23);
//   %wire_19 = &"VIN" @WIRE(mode="straight") {%p19 #"M39":1};
//   %p20 = (33, 23);
//   %wire_20 = &"VIN" @WIRE(mode="straight") {%p20 #"M37":1};
//   %p21 = (56, 23);
//   %wire_21 = &"VIN" @WIRE(mode="straight") {%p21 #"M36":1};
//   %p22 = (79, 23);
//   %wire_22 = &"VIN" @WIRE(mode="straight") {%p22 #"M127":1};
//   %p23 = (-34, 23);
//   %wire_23 = &"VIN" @WIRE(mode="straight") {%p23 #"M40":1};
//   %p24 = (11, 23);
//   %wire_24 = &"VIN" @WIRE(mode="straight") {%p24 #"M38":1};
//   %p25 = (-106, 14);
//   %p26 = (-106, 18);
//   %wire_25 = &"VIN" @WIRE(mode="straight") {%p25 %p26};
//   %p27 = (-121, 23);
//   %wire_26 = &"VIN" @WIRE(mode="straight") {%p27 #"M15":1};
//   %wire_25 @TEXT("VIN", size=1, halign="start", valign="baseline", rotate=90) => @PLACE(-106.7, 15.3);
//   %wire_26 @TEXT("VIN", size=1, halign="end", valign="baseline") => @PLACE(-117.2, 23.7);
//   %wire_21 @TEXT("VIN", size=1, halign="end", valign="top") => @PLACE(59.8, 22.3);
//   %wire_22 @TEXT("VIN", size=1, halign="end", valign="top") => @PLACE(82.8, 22.3);
//   %wire_20 @TEXT("VIN", size=1, halign="end", valign="top") => @PLACE(36.8, 22.3);
//   %wire_24 @TEXT("VIN", size=1, halign="end", valign="top") => @PLACE(14.8, 22.3);
//   %wire_19 @TEXT("VIN", size=1, halign="end", valign="top") => @PLACE(-7.2, 22.3);
//   %wire_23 @TEXT("VIN", size=1, halign="end", valign="top") => @PLACE(-30.2, 22.3);
//   %wire_18 @TEXT("VIN", size=1, halign="end", valign="top") => @PLACE(-51.2, 22.3);
//   %wire_17 @TEXT("VIN", size=1, halign="end", valign="top") => @PLACE(-72.2, 22.3);
//   %wire_16 @TEXT("VIN", size=1, halign="end", valign="top") => @PLACE(-93.2, 22.3);
//   %p28 = (-90, 31);
//   %wire_27 = &"VBST" @WIRE(mode="straight") {%p28 #"M43":2};
//   %p29 = (-69, 31);
//   %wire_28 = &"VBST" @WIRE(mode="straight") {%p29 #"M42":2};
//   %p30 = (-48, 31);
//   %wire_29 = &"VBST" @WIRE(mode="straight") {%p30 #"M41":2};
//   %p31 = (-27, 31);
//   %wire_30 = &"VBST" @WIRE(mode="straight") {%p31 #"M40":2};
//   %p32 = (-4, 31);
//   %wire_31 = &"VBST" @WIRE(mode="straight") {%p32 #"M39":2};
//   %p33 = (18, 31);
//   %wire_32 = &"VBST" @WIRE(mode="straight") {%p33 #"M38":2};
//   %p34 = (40, 31);
//   %wire_33 = &"VBST" @WIRE(mode="straight") {%p34 #"M37":2};
//   %p35 = (86, 31);
//   %wire_34 = &"VBST" @WIRE(mode="straight") {%p35 #"M127":2};
//   %p36 = (63, 31);
//   %wire_35 = &"VBST" @WIRE(mode="straight") {%p36 #"M36":2};
//   %p37 = (-102, 14);
//   %p38 = (-102, 18);
//   %wire_36 = &"VBST" @WIRE(mode="straight") {%p37 %p38};
//   %p39 = (-114, 15);
//   %wire_37 = &"VBST" @WIRE(mode="straight") {%p39 #"M15":2};
//   %wire_37 @TEXT("VBST", size=1, halign="middle", valign="baseline", rotate=90) => @PLACE(-114.7, 17);
//   %wire_35 @TEXT("VBST", size=1, halign="start", valign="baseline", rotate=90) => @PLACE(62.3, 27.2);
//   %wire_36 @TEXT("VBST", size=1, halign="start", valign="baseline", rotate=90) => @PLACE(-102.7, 14.4);
//   %wire_34 @TEXT("VBST", size=1, halign="start", valign="baseline", rotate=90) => @PLACE(85.3, 27.2);
//   %wire_32 @TEXT("VBST", size=1, halign="start", valign="baseline", rotate=90) => @PLACE(17.3, 27.2);
//   %wire_33 @TEXT("VBST", size=1, halign="start", valign="baseline", rotate=90) => @PLACE(39.3, 27.2);
//   %wire_31 @TEXT("VBST", size=1, halign="start", valign="baseline", rotate=90) => @PLACE(-4.7, 27.2);
//   %wire_30 @TEXT("VBST", size=1, halign="start", valign="baseline", rotate=90) => @PLACE(-27.7, 27.2);
//   %wire_29 @TEXT("VBST", size=1, halign="start", valign="baseline", rotate=90) => @PLACE(-48.7, 27.2);
//   %wire_28 @TEXT("VBST", size=1, halign="start", valign="baseline", rotate=90) => @PLACE(-69.7, 27.2);
//   %wire_27 @TEXT("VBST", size=1, halign="start", valign="baseline", rotate=90) => @PLACE(-90.7, 27.2);
//   %p40 = (-89, 18);
//   %wire_38 = &"VSS" @WIRE(mode="straight") {#"M43":4 %p40};
//   %p41 = (-68, 18);
//   %wire_39 = &"VSS" @WIRE(mode="straight") {#"M42":4 %p41};
//   %p42 = (-47, 18);
//   %wire_40 = &"VSS" @WIRE(mode="straight") {#"M41":4 %p42};
//   %p43 = (-26, 18);
//   %wire_41 = &"VSS" @WIRE(mode="straight") {#"M40":4 %p43};
//   %p44 = (-13, 14);
//   %wire_42 = &"VSS" @WIRE(mode="straight") {#"M31":4 %p44};
//   %p45 = (10, 14);
//   %wire_43 = &"VSS" @WIRE(mode="straight") {#"M29":4 %p45};
//   %p46 = (32, 14);
//   %wire_44 = &"VSS" @WIRE(mode="straight") {#"M28":4 %p46};
//   %p47 = (54, 14);
//   %wire_45 = &"VSS" @WIRE(mode="straight") {#"M27":4 %p47};
//   %p48 = (-3, 18);
//   %wire_46 = &"VSS" @WIRE(mode="straight") {#"M39":4 %p48};
//   %p49 = (-34, 14);
//   %wire_47 = &"VSS" @WIRE(mode="straight") {#"M32":4 %p49};
//   %p50 = (-55, 14);
//   %wire_48 = &"VSS" @WIRE(mode="straight") {#"M33":4 %p50};
//   %p51 = (-102, 4);
//   %p52 = (-102, 8);
//   %wire_49 = &"VSS" @WIRE(mode="straight") {%p51 %p52};
//   %p53 = (100, 14);
//   %wire_50 = &"VSS" @WIRE(mode="straight") {#"M99":4 %p53};
//   %p54 = (77, 14);
//   %wire_51 = &"VSS" @WIRE(mode="straight") {#"M26":4 %p54};
//   %p55 = (19, 18);
//   %wire_52 = &"VSS" @WIRE(mode="straight") {#"M38":4 %p55};
//   %p56 = (41, 18);
//   %wire_53 = &"VSS" @WIRE(mode="straight") {#"M37":4 %p56};
//   %p57 = (87, 18);
//   %wire_54 = &"VSS" @WIRE(mode="straight") {#"M127":4 %p57};
//   %p58 = (-76, 14);
//   %wire_55 = &"VSS" @WIRE(mode="straight") {#"M34":4 %p58};
//   %p59 = (64, 18);
//   %wire_56 = &"VSS" @WIRE(mode="straight") {#"M36":4 %p59};
//   %p60 = (-113, 28);
//   %wire_57 = &"VSS" @WIRE(mode="straight") {#"M15":4 %p60};
//   %wire_54 @TEXT("VSS", size=1, halign="middle", valign="baseline", rotate=90) => @PLACE(86.3, 20);
//   %wire_57 @TEXT("VSS", size=1, halign="middle", valign="baseline", rotate=90) => @PLACE(-113.7, 26);
//   %wire_56 @TEXT("VSS", size=1, halign="middle", valign="baseline", rotate=90) => @PLACE(63.3, 20);
//   %wire_55 @TEXT("VSS", size=1, halign="middle", valign="baseline") => @PLACE(-78, 14.7);
//   %wire_53 @TEXT("VSS", size=1, halign="middle", valign="baseline", rotate=90) => @PLACE(40.3, 20);
//   %wire_51 @TEXT("VSS", size=1, halign="middle", valign="baseline") => @PLACE(75, 14.7);
//   %wire_50 @TEXT("VSS", size=1, halign="middle", valign="baseline") => @PLACE(98, 14.7);
//   %wire_48 @TEXT("VSS", size=1, halign="middle", valign="baseline") => @PLACE(-57, 14.7);
//   %wire_47 @TEXT("VSS", size=1, halign="middle", valign="baseline") => @PLACE(-36, 14.7);
//   %wire_52 @TEXT("VSS", size=1, halign="middle", valign="baseline", rotate=90) => @PLACE(18.3, 20);
//   %wire_45 @TEXT("VSS", size=1, halign="middle", valign="baseline") => @PLACE(52, 14.7);
//   %wire_44 @TEXT("VSS", size=1, halign="middle", valign="baseline") => @PLACE(30, 14.7);
//   %wire_43 @TEXT("VSS", size=1, halign="middle", valign="baseline") => @PLACE(8, 14.7);
//   %wire_42 @TEXT("VSS", size=1, halign="middle", valign="baseline") => @PLACE(-15, 14.7);
//   %wire_46 @TEXT("VSS", size=1, halign="middle", valign="baseline", rotate=90) => @PLACE(-3.7, 20);
//   %wire_41 @TEXT("VSS", size=1, halign="middle", valign="baseline", rotate=90) => @PLACE(-26.7, 20);
//   %wire_40 @TEXT("VSS", size=1, halign="middle", valign="baseline", rotate=90) => @PLACE(-47.7, 20);
//   %wire_39 @TEXT("VSS", size=1, halign="middle", valign="baseline", rotate=90) => @PLACE(-68.7, 20);
//   %wire_38 @TEXT("VSS", size=1, halign="middle", valign="baseline", rotate=90) => @PLACE(-89.7, 20);
//   %wire_49 @TEXT("VSS", size=1, halign="end", valign="baseline", rotate=90) => @PLACE(-102.7, 7.6);
//   %p61 = (-18, 7);
//   %wire_58 = &"VREFN" @WIRE(mode="straight") {%p61 #"M31":3};
//   %p62 = (5, 7);
//   %wire_59 = &"VREFN" @WIRE(mode="straight") {%p62 #"M29":3};
//   %p63 = (27, 7);
//   %wire_60 = &"VREFN" @WIRE(mode="straight") {%p63 #"M28":3};
//   %p64 = (49, 7);
//   %wire_61 = &"VREFN" @WIRE(mode="straight") {%p64 #"M27":3};
//   %p65 = (-39, 7);
//   %wire_62 = &"VREFN" @WIRE(mode="straight") {%p65 #"M32":3};
//   %p66 = (-60, 7);
//   %wire_63 = &"VREFN" @WIRE(mode="straight") {%p66 #"M33":3};
//   %p67 = (95, 7);
//   %wire_64 = &"VREFN" @WIRE(mode="straight") {%p67 #"M99":3};
//   %p68 = (72, 7);
//   %wire_65 = &"VREFN" @WIRE(mode="straight") {%p68 #"M26":3};
//   %p69 = (-81, 7);
//   %wire_66 = &"VREFN" @WIRE(mode="straight") {%p69 #"M34":3};
//   %wire_66 @TEXT("VREFN", size=1, halign="middle", valign="baseline", rotate=90) => @PLACE(-81.7, 9);
//   %wire_65 @TEXT("VREFN", size=1, halign="middle", valign="baseline", rotate=90) => @PLACE(71.3, 9);
//   %wire_64 @TEXT("VREFN", size=1, halign="middle", valign="baseline", rotate=90) => @PLACE(94.3, 9);
//   %wire_63 @TEXT("VREFN", size=1, halign="middle", valign="baseline", rotate=90) => @PLACE(-60.7, 9);
//   %wire_62 @TEXT("VREFN", size=1, halign="middle", valign="baseline", rotate=90) => @PLACE(-39.7, 9);
//   %wire_61 @TEXT("VREFN", size=1, halign="middle", valign="baseline", rotate=90) => @PLACE(48.3, 9);
//   %wire_60 @TEXT("VREFN", size=1, halign="middle", valign="baseline", rotate=90) => @PLACE(26.3, 9);
//   %wire_59 @TEXT("VREFN", size=1, halign="middle", valign="baseline", rotate=90) => @PLACE(4.3, 9);
//   %wire_58 @TEXT("VREFN", size=1, halign="middle", valign="baseline", rotate=90) => @PLACE(-18.7, 9);
//   %p70 = (87, 15);
//   %wire_67 = &"RN_9" @WIRE(mode="straight") {%p70 #"M99":2};
//   %wire_67 @TEXT("RN\_9", size=1, halign="middle", valign="baseline") => @PLACE(89, 15.7);
//   %p71 = (64, 15);
//   %wire_68 = &"RN_8" @WIRE(mode="straight") {%p71 #"M26":2};
//   %wire_68 @TEXT("RN\_8", size=1, halign="middle", valign="baseline") => @PLACE(66, 15.7);
//   %p72 = (41, 15);
//   %wire_69 = &"RN_7" @WIRE(mode="straight") {%p72 #"M27":2};
//   %wire_69 @TEXT("RN\_7", size=1, halign="middle", valign="baseline") => @PLACE(43, 15.7);
//   %p73 = (19, 15);
//   %wire_70 = &"RN_6" @WIRE(mode="straight") {%p73 #"M28":2};
//   %wire_70 @TEXT("RN\_6", size=1, halign="middle", valign="baseline") => @PLACE(21, 15.7);
//   %p74 = (-3, 15);
//   %wire_71 = &"RN_5" @WIRE(mode="straight") {%p74 #"M29":2};
//   %wire_71 @TEXT("RN\_5", size=1, halign="middle", valign="baseline") => @PLACE(-1, 15.7);
//   %p75 = (-26, 15);
//   %wire_72 = &"RN_4" @WIRE(mode="straight") {%p75 #"M31":2};
//   %wire_72 @TEXT("RN\_4", size=1, halign="middle", valign="baseline") => @PLACE(-24, 15.7);
//   %p76 = (87, 33);
//   %wire_73 = &"RP_9" @WIRE(mode="straight") {%p76 #"M105":2};
//   %wire_73 @TEXT("RP\_9", size=1, halign="middle", valign="baseline") => @PLACE(89, 33.7);
//   %p77 = (64, 33);
//   %wire_74 = &"RP_8" @WIRE(mode="straight") {%p77 #"M4":2};
//   %wire_74 @TEXT("RP\_8", size=1, halign="middle", valign="baseline") => @PLACE(66, 33.7);
//   %p78 = (41, 33);
//   %wire_75 = &"RP_7" @WIRE(mode="straight") {%p78 #"M5":2};
//   %wire_75 @TEXT("RP\_7", size=1, halign="middle", valign="baseline") => @PLACE(43, 33.7);
//   %p79 = (19, 33);
//   %wire_76 = &"RP_6" @WIRE(mode="straight") {%p79 #"M6":2};
//   %wire_76 @TEXT("RP\_6", size=1, halign="middle", valign="baseline") => @PLACE(21, 33.7);
//   %p80 = (-3, 33);
//   %wire_77 = &"RP_5" @WIRE(mode="straight") {%p80 #"M7":2};
//   %wire_77 @TEXT("RP\_5", size=1, halign="middle", valign="baseline") => @PLACE(-1, 33.7);
//   %p81 = (-26, 33);
//   %wire_78 = &"RP_4" @WIRE(mode="straight") {%p81 #"M8":2};
//   %wire_78 @TEXT("RP\_4", size=1, halign="middle", valign="baseline") => @PLACE(-24, 33.7);
//   %p82 = (95, 23);
//   %wire_79 = &"BOT_9" @WIRE(mode="straight") {#"M99":1 %p82};
//   %wire_80 = &"BOT_9" @WIRE(mode="straight") {#"M127":3 %p82};
//   %wire_81 = &"BOT_9" @WIRE(mode="straight") {%p82 #"M105":1};
//   %wire_81 @TEXT("BOT\_9", size=1, halign="middle", valign="baseline", rotate=90) => @PLACE(94.3, 25);
//   %p83 = (72, 23);
//   %wire_82 = &"BOT_8" @WIRE(mode="straight") {#"M26":1 %p83};
//   %wire_83 = &"BOT_8" @WIRE(mode="straight") {#"M36":3 %p83};
//   %wire_84 = &"BOT_8" @WIRE(mode="straight") {%p83 #"M4":1};
//   %wire_84 @TEXT("BOT\_8", size=1, halign="middle", valign="baseline", rotate=90) => @PLACE(71.3, 25);
//   %p84 = (49, 23);
//   %wire_85 = &"BOT_7" @WIRE(mode="straight") {#"M27":1 %p84};
//   %wire_86 = &"BOT_7" @WIRE(mode="straight") {%p84 #"M5":1};
//   %wire_87 = &"BOT_7" @WIRE(mode="straight") {#"M37":3 %p84};
//   %wire_86 @TEXT("BOT\_7", size=1, halign="middle", valign="baseline", rotate=90) => @PLACE(48.3, 25);
//   %p85 = (27, 23);
//   %wire_88 = &"BOT_6" @WIRE(mode="straight") {#"M28":1 %p85};
//   %wire_89 = &"BOT_6" @WIRE(mode="straight") {#"M38":3 %p85};
//   %wire_90 = &"BOT_6" @WIRE(mode="straight") {%p85 #"M6":1};
//   %wire_90 @TEXT("BOT\_6", size=1, halign="middle", valign="baseline", rotate=90) => @PLACE(26.3, 25);
//   %p86 = (5, 23);
//   %wire_91 = &"BOT_5" @WIRE(mode="straight") {%p86 #"M7":1};
//   %wire_92 = &"BOT_5" @WIRE(mode="straight") {#"M39":3 %p86};
//   %wire_93 = &"BOT_5" @WIRE(mode="straight") {#"M29":1 %p86};
//   %wire_91 @TEXT("BOT\_5", size=1, halign="middle", valign="baseline", rotate=90) => @PLACE(4.3, 25);
//   %p87 = (-106, 4);
//   %p88 = (-106, 8);
//   %wire_94 = {&"BOT_9" &"BOT_8" &"BOT_7" &"BOT_6" &"BOT_5" &"BOT_4" &"BOT_3" &"BOT_2" &"BOT_1" &"BOT_0"} @WIRE(mode="straight") {%p87 %p88};
//   %wire_94 @TEXT("BOT<0:9>", size=1, halign="middle", valign="baseline", rotate=90) => @PLACE(-106.7, 6);
//   %p89 = (-104, 23);
//   %wire_95 = &"BOT_0" @WIRE(mode="straight") {%p89 #"M0":1};
//   %wire_96 = &"BOT_0" @WIRE(mode="straight") {%p89 #"M15":3};
//   %wire_95 @TEXT("BOT\_0", size=1, halign="middle", valign="baseline", rotate=90) => @PLACE(-104.7, 27);
//   %p90 = (-81, 23);
//   %wire_97 = &"BOT_1" @WIRE(mode="straight") {#"M43":3 %p90};
//   %wire_98 = &"BOT_1" @WIRE(mode="straight") {%p90 #"M12":1};
//   %wire_99 = &"BOT_1" @WIRE(mode="straight") {#"M34":1 %p90};
//   %wire_98 @TEXT("BOT\_1", size=1, halign="middle", valign="baseline", rotate=90) => @PLACE(-81.7, 25);
//   %p91 = (-60, 23);
//   %wire_100 = &"BOT_2" @WIRE(mode="straight") {#"M42":3 %p91};
//   %wire_101 = &"BOT_2" @WIRE(mode="straight") {%p91 #"M9":1};
//   %wire_102 = &"BOT_2" @WIRE(mode="straight") {#"M33":1 %p91};
//   %wire_101 @TEXT("BOT\_2", size=1, halign="middle", valign="baseline", rotate=90) => @PLACE(-60.7, 25);
//   %p92 = (-39, 23);
//   %wire_103 = &"BOT_3" @WIRE(mode="straight") {%p92 #"M10":1};
//   %wire_104 = &"BOT_3" @WIRE(mode="straight") {#"M41":3 %p92};
//   %wire_105 = &"BOT_3" @WIRE(mode="straight") {#"M32":1 %p92};
//   %wire_103 @TEXT("BOT\_3", size=1, halign="middle", valign="baseline", rotate=90) => @PLACE(-39.7, 25);
//   %p93 = (-14, 34);
//   %wire_106 = &"VDD" @WIRE(mode="straight") {#"M8":4 %p93};
//   %p94 = (9, 34);
//   %wire_107 = &"VDD" @WIRE(mode="straight") {#"M7":4 %p94};
//   %p95 = (31, 34);
//   %wire_108 = &"VDD" @WIRE(mode="straight") {#"M6":4 %p95};
//   %p96 = (53, 34);
//   %wire_109 = &"VDD" @WIRE(mode="straight") {#"M5":4 %p96};
//   %p97 = (76, 34);
//   %wire_110 = &"VDD" @WIRE(mode="straight") {#"M4":4 %p97};
//   %p98 = (-35, 34);
//   %wire_111 = &"VDD" @WIRE(mode="straight") {#"M10":4 %p98};
//   %p99 = (-56, 34);
//   %wire_112 = &"VDD" @WIRE(mode="straight") {#"M9":4 %p99};
//   %p100 = (99, 34);
//   %wire_113 = &"VDD" @WIRE(mode="straight") {#"M105":4 %p100};
//   %p101 = (-77, 34);
//   %wire_114 = &"VDD" @WIRE(mode="straight") {#"M12":4 %p101};
//   %p102 = (-100, 33);
//   %wire_115 = &"VDD" @WIRE(mode="straight") {#"M0":4 %p102};
//   %wire_114 @TEXT("VDD", size=1, halign="middle", valign="baseline") => @PLACE(-79, 34.7);
//   %wire_115 @TEXT("VDD", size=1, halign="middle", valign="baseline") => @PLACE(-102, 33.7);
//   %wire_113 @TEXT("VDD", size=1, halign="middle", valign="baseline") => @PLACE(97, 34.7);
//   %wire_112 @TEXT("VDD", size=1, halign="middle", valign="baseline") => @PLACE(-58, 34.7);
//   %wire_111 @TEXT("VDD", size=1, halign="middle", valign="baseline") => @PLACE(-37, 34.7);
//   %wire_110 @TEXT("VDD", size=1, halign="middle", valign="baseline") => @PLACE(74, 34.7);
//   %wire_109 @TEXT("VDD", size=1, halign="middle", valign="baseline") => @PLACE(51, 34.7);
//   %wire_108 @TEXT("VDD", size=1, halign="middle", valign="baseline") => @PLACE(29, 34.7);
//   %wire_107 @TEXT("VDD", size=1, halign="middle", valign="baseline") => @PLACE(7, 34.7);
//   %wire_106 @TEXT("VDD", size=1, halign="middle", valign="baseline") => @PLACE(-16, 34.7);
//   %p103 = (-18, 23);
//   %wire_116 = &"BOT_4" @WIRE(mode="straight") {%p103 #"M8":1};
//   %wire_117 = &"BOT_4" @WIRE(mode="straight") {#"M40":3 %p103};
//   %wire_118 = &"BOT_4" @WIRE(mode="straight") {#"M31":1 %p103};
//   %wire_116 @TEXT("BOT\_4", size=1, halign="middle", valign="baseline", rotate=90) => @PLACE(-18.7, 25);
//   %p104 = (-113, 32);
//   %wire_119 = &"DACENB" @WIRE(mode="straight") {%p104 #"M0":2};
//   %wire_119 @TEXT("DACENB", size=1, halign="middle", valign="baseline") => @PLACE(-110, 32.7);
//   $JUNCTION @ATTACH %p82;
//   $JUNCTION @ATTACH %p83;
//   $JUNCTION @ATTACH %p84;
//   $JUNCTION @ATTACH %p85;
//   $JUNCTION @ATTACH %p86;
//   $JUNCTION @ATTACH %p90;
//   $JUNCTION @ATTACH %p91;
//   $JUNCTION @ATTACH %p92;
//   $JUNCTION @ATTACH %p103
// }
// @RNL(author="native-ignored-figure-recovery") {
//   %ignored_symbol_3 = @DEFINE-SYMBOL(box=[0, -6, 4, 0]) {
//     @LINE {(4, -6) (4, -4.5) (1.5, -4.5)};
//     @LINE {(0, 0) (0, -2)};
//     @LINE {(1.5, -1.5) (4, -1.5) (4, 0)};
//     @LINE {(-1, -4) (0, -2)};
//     @LINE {(0, -4) (0, -6)};
//     @ARC {(1.5, -1.5) (1, -2) (1.5, -2.5)};
//     @ARC {(1.5, -2.5) (1, -3) (1.5, -3.5)};
//     @ARC {(1.5, -3.5) (1, -4) (1.5, -4.5)};
//     ? @TEXT("${name}", size=0.8, halign="start", valign="baseline", key="name") => @PLACE(5, -1);
//     (4, 0) @CIRCLE(radius=0.12);
//     (4, -6) @CIRCLE(radius=0.12);
//     (0, 0) @CIRCLE(radius=0.12);
//     (0, -6) @CIRCLE(radius=0.12)
//   };
//   %ignored_3 = $FIGURE @ATTACH (-106, 14) => @SET-SYMBOL %ignored_symbol_3 => @ORIENT("R0");
//   %ignored_3 @TEXT("W0<0:9>", key="name");
//   %ignored_3 @TEXT("switch", key="model")
// }
ends RS9_L6_9bit_RSW
