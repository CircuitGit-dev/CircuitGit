simulator lang=spectre
global 0
include "project.scs"

VVDD (vdd 0) vsource type=dc dc=1.8
VIN (in 0) vsource type=pulse val0=0 val1=1.8 delay=1n rise=50p fall=50p width=4n period=10n
XINV (in out vdd 0) OPEN_CMOS_INVERTER
CLOAD (out 0) capacitor c=20f

tran tran stop=10n maxstep=20p
save in out
saveOptions options save=selected
