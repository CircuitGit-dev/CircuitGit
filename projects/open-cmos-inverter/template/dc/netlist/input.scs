simulator lang=spectre
global 0
include "project.scs"

VVDD (vdd 0) vsource type=dc dc=1.8
VIN (in 0) vsource type=dc dc=0.9
XINV (in out vdd 0) OPEN_CMOS_INVERTER
CLOAD (out 0) capacitor c=20f

dc_vtc dc dev=VIN param=dc start=0 stop=1.8 step=0.02
save in out
saveOptions options save=selected
